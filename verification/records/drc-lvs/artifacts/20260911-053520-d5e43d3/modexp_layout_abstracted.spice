* extracted by klt extract --deck sky130

* cell modexp
* pin VDD
* pin VSS
* pin _0000_
* pin _0001_
* pin _0002_
* pin _0003_
* pin _0004_
* pin _0005_
* pin _0006_
* pin _0007_
* pin _0008_
* pin _0009_
* pin _0010_
* pin _0011_
* pin _0012_
* pin _0013_
* pin _0014_
* pin _0015_
* pin _0016_
* pin _0017_
* pin _0018_
* pin _0019_
* pin _0020_
* pin _0021_
* pin _0022_
* pin _0023_
* pin _0024_
* pin _0025_
* pin _0026_
* pin _0027_
* pin _0028_
* pin _0029_
* pin _0030_
* pin _0031_
* pin _0032_
* pin _0033_
* pin _0034_
* pin _0035_
* pin _0036_
* pin _0037_
* pin _0038_
* pin _0039_
* pin _0040_
* pin _0041_
* pin _0042_
* pin _0043_
* pin _0044_
* pin _0045_
* pin _0046_
* pin _0047_
* pin _0048_
* pin _0049_
* pin _0050_
* pin _0051_
* pin _0052_
* pin _0053_
* pin _0054_
* pin _0055_
* pin _0056_
* pin _0057_
* pin _0058_
* pin _0059_
* pin _0060_
* pin _0061_
* pin _0062_
* pin _0063_
* pin _0064_
* pin _0065_
* pin _0066_
* pin _0067_
* pin _0068_
* pin _0069_
* pin _0070_
* pin _0071_
* pin _0072_
* pin _0073_
* pin _0074_
* pin _0075_
* pin _0076_
* pin _0077_
* pin _0078_
* pin _0079_
* pin _0080_
* pin _0081_
* pin _0082_
* pin _0083_
* pin _0084_
* pin _0085_
* pin _0086_
* pin _0087_
* pin _0088_
* pin _0089_
* pin _0090_
* pin _0091_
* pin _0092_
* pin _0093_
* pin _0094_
* pin _0095_
* pin _0096_
* pin _0097_
* pin _0098_
* pin _0099_
* pin _0100_
* pin _0101_
* pin _0102_
* pin _0103_
* pin _0104_
* pin _0105_
* pin _0106_
* pin _0107_
* pin _0108_
* pin _0109_
* pin _0110_
* pin _0111_
* pin _0112_
* pin _0113_
* pin _0114_
* pin _0115_
* pin _0116_
* pin _0117_
* pin _0118_
* pin _0119_
* pin _0120_
* pin _0121_
* pin _0122_
* pin _0123_
* pin _0124_
* pin _0125_
* pin _0126_
* pin _0127_
* pin _0128_
* pin _0129_
* pin _0130_
* pin _0131_
* pin _0132_
* pin _0133_
* pin _0134_
* pin _0135_
* pin _0136_
* pin _0137_
* pin _0138_
* pin _0139_
* pin _0140_
* pin _0141_
* pin _0142_
* pin _0143_
* pin _0144_
* pin _0145_
* pin _0146_
* pin _0147_
* pin _0148_
* pin _0149_
* pin _0150_
* pin _0151_
* pin _0152_
* pin _0153_
* pin _0154_
* pin _0155_
* pin _0156_
* pin _0157_
* pin _0158_
* pin _0159_
* pin _0160_
* pin _0161_
* pin _0162_
* pin _0163_
* pin _0164_
* pin _0165_
* pin _0166_
* pin _0167_
* pin _0168_
* pin _0169_
* pin _0170_
* pin _0171_
* pin _0172_
* pin _0173_
* pin _0174_
* pin _0175_
* pin _0176_
* pin _0177_
* pin _0178_
* pin _0179_
* pin _0180_
* pin _0181_
* pin _0182_
* pin _0183_
* pin _0184_
* pin _0185_
* pin _0186_
* pin _0187_
* pin _0188_
* pin _0189_
* pin _0190_
* pin _0191_
* pin _0192_
* pin _0193_
* pin _0194_
* pin _0195_
* pin _0196_
* pin _0197_
* pin _0198_
* pin _0199_
* pin _0200_
* pin _0201_
* pin _0202_
* pin _0203_
* pin _0204_
* pin _0205_
* pin _0206_
* pin _0207_
* pin _0208_
* pin _0209_
* pin _0210_
* pin _0211_
* pin _0212_
* pin _0213_
* pin _0214_
* pin _0215_
* pin _0216_
* pin _0217_
* pin _0218_
* pin _0219_
* pin _0220_
* pin _0221_
* pin _0222_
* pin _0223_
* pin _0224_
* pin _0225_
* pin _0226_
* pin _0227_
* pin _0228_
* pin _0229_
* pin _0230_
* pin _0231_
* pin _0232_
* pin _0233_
* pin _0234_
* pin _0235_
* pin _0236_
* pin _0237_
* pin _0238_
* pin _0239_
* pin _0240_
* pin _0241_
* pin _0242_
* pin _0243_
* pin _0244_
* pin _0245_
* pin _0246_
* pin _0247_
* pin _0248_
* pin _0249_
* pin _0250_
* pin _0251_
* pin _0252_
* pin _0253_
* pin _0254_
* pin _0255_
* pin _0256_
* pin _0257_
* pin _0258_
* pin _0259_
* pin _0260_
* pin _0261_
* pin _0262_
* pin _0263_
* pin _0264_
* pin _0265_
* pin _0266_
* pin _0267_
* pin _0268_
* pin _0269_
* pin _0270_
* pin _0271_
* pin _0272_
* pin _0273_
* pin _0274_
* pin _0275_
* pin _0276_
* pin _0277_
* pin _0278_
* pin _0279_
* pin _0280_
* pin _0281_
* pin _0282_
* pin _0283_
* pin _0284_
* pin _0285_
* pin _0286_
* pin _0287_
* pin _0288_
* pin _0289_
* pin _0290_
* pin _0291_
* pin _0292_
* pin _0293_
* pin _0294_
* pin _0295_
* pin _0296_
* pin _0297_
* pin _0298_
* pin _0299_
* pin _0300_
* pin _0301_
* pin _0302_
* pin _0303_
* pin _0304_
* pin _0305_
* pin _0306_
* pin _0307_
* pin _0308_
* pin _0309_
* pin _0310_
* pin _0311_
* pin _0312_
* pin _0313_
* pin _0314_
* pin _0315_
* pin _0316_
* pin _0317_
* pin _0318_
* pin _0319_
* pin _0320_
* pin _0321_
* pin _0322_
* pin _0323_
* pin _0324_
* pin _0325_
* pin _0326_
* pin _0327_
* pin _0328_
* pin _0329_
* pin _0330_
* pin _0331_
* pin _0332_
* pin _0333_
* pin _0334_
* pin _0335_
* pin _0336_
* pin _0337_
* pin _0338_
* pin _0339_
* pin _0340_
* pin _0341_
* pin _0342_
* pin _0343_
* pin _0344_
* pin _0345_
* pin _0346_
* pin _0347_
* pin _0348_
* pin _0349_
* pin _0350_
* pin _0351_
* pin _0352_
* pin _0353_
* pin _0354_
* pin _0355_
* pin _0356_
* pin _0357_
* pin _0358_
* pin _0359_
* pin _0360_
* pin _0361_
* pin _0362_
* pin _0363_
* pin _0364_
* pin _0365_
* pin _0366_
* pin _0367_
* pin _0368_
* pin _0369_
* pin _0370_
* pin _0371_
* pin _0372_
* pin _0373_
* pin _0374_
* pin _0375_
* pin _0376_
* pin _0377_
* pin _0378_
* pin _0379_
* pin _0380_
* pin _0381_
* pin _0382_
* pin _0383_
* pin _0384_
* pin _0385_
* pin _0386_
* pin _0387_
* pin _0388_
* pin _0389_
* pin _0390_
* pin _0391_
* pin _0392_
* pin _0393_
* pin _0394_
* pin _0395_
* pin _0396_
* pin _0397_
* pin _0398_
* pin _0399_
* pin _0400_
* pin _0401_
* pin _0402_
* pin _0403_
* pin _0404_
* pin _0405_
* pin _0406_
* pin _0407_
* pin _0408_
* pin _0409_
* pin _0410_
* pin _0411_
* pin _0412_
* pin _0413_
* pin _0414_
* pin _0415_
* pin _0416_
* pin _0417_
* pin _0418_
* pin _0419_
* pin _0420_
* pin _0421_
* pin _0422_
* pin _0423_
* pin _0424_
* pin _0425_
* pin _0426_
* pin _0427_
* pin _0428_
* pin _0429_
* pin _0430_
* pin _0431_
* pin _0432_
* pin _0433_
* pin _0434_
* pin _0435_
* pin _0436_
* pin _0437_
* pin _0438_
* pin _0439_
* pin _0440_
* pin _0441_
* pin _0442_
* pin _0443_
* pin _0444_
* pin _0445_
* pin _0446_
* pin _0447_
* pin _0448_
* pin _0449_
* pin _0450_
* pin _0451_
* pin _0452_
* pin _0453_
* pin _0454_
* pin _0455_
* pin _0456_
* pin _0457_
* pin _0458_
* pin _0459_
* pin _0460_
* pin _0461_
* pin _0462_
* pin _0463_
* pin _0464_
* pin _0465_
* pin _0466_
* pin _0467_
* pin _0468_
* pin _0469_
* pin _0470_
* pin _0471_
* pin _0472_
* pin _0473_
* pin _0474_
* pin _0475_
* pin _0476_
* pin _0477_
* pin _0478_
* pin _0479_
* pin _0480_
* pin _0481_
* pin _0482_
* pin _0483_
* pin _0484_
* pin _0485_
* pin _0486_
* pin _0487_
* pin _0488_
* pin _0489_
* pin _0490_
* pin _0491_
* pin _0492_
* pin _0493_
* pin _0494_
* pin _0495_
* pin _0496_
* pin _0497_
* pin _0498_
* pin _0499_
* pin _0500_
* pin _0501_
* pin _0502_
* pin _0503_
* pin _0504_
* pin _0505_
* pin _0506_
* pin _0507_
* pin _0508_
* pin _0509_
* pin _0510_
* pin _0511_
* pin _0512_
* pin _0513_
* pin _0514_
* pin _0515_
* pin _0516_
* pin _0517_
* pin _0518_
* pin _0519_
* pin _0520_
* pin _0521_
* pin _0522_
* pin _0523_
* pin _0524_
* pin _0525_
* pin _0526_
* pin _0527_
* pin _0528_
* pin _0529_
* pin _0530_
* pin _0531_
* pin _0532_
* pin _0533_
* pin _0534_
* pin _0535_
* pin _0536_
* pin _0537_
* pin _0538_
* pin _0539_
* pin _0540_
* pin _0541_
* pin _0542_
* pin _0543_
* pin _0544_
* pin _0545_
* pin _0546_
* pin _0547_
* pin _0548_
* pin _0549_
* pin _0550_
* pin _0551_
* pin _tie_zero_
* pin base_in[0]
* pin base_in[10]
* pin base_in[11]
* pin base_in[12]
* pin base_in[13]
* pin base_in[14]
* pin base_in[15]
* pin base_in[1]
* pin base_in[2]
* pin base_in[3]
* pin base_in[4]
* pin base_in[5]
* pin base_in[6]
* pin base_in[7]
* pin base_in[8]
* pin base_in[9]
* pin base_r[0]
* pin base_r[10]
* pin base_r[11]
* pin base_r[12]
* pin base_r[13]
* pin base_r[14]
* pin base_r[15]
* pin base_r[1]
* pin base_r[2]
* pin base_r[3]
* pin base_r[4]
* pin base_r[5]
* pin base_r[6]
* pin base_r[7]
* pin base_r[8]
* pin base_r[9]
* pin clk
* pin clknet_0_clk
* pin clknet_4_0_0_clk
* pin clknet_4_10_0_clk
* pin clknet_4_11_0_clk
* pin clknet_4_12_0_clk
* pin clknet_4_13_0_clk
* pin clknet_4_14_0_clk
* pin clknet_4_15_0_clk
* pin clknet_4_1_0_clk
* pin clknet_4_2_0_clk
* pin clknet_4_3_0_clk
* pin clknet_4_4_0_clk
* pin clknet_4_5_0_clk
* pin clknet_4_6_0_clk
* pin clknet_4_7_0_clk
* pin clknet_4_8_0_clk
* pin clknet_4_9_0_clk
* pin done
* pin exp_in[0]
* pin exp_in[10]
* pin exp_in[11]
* pin exp_in[12]
* pin exp_in[13]
* pin exp_in[14]
* pin exp_in[15]
* pin exp_in[1]
* pin exp_in[2]
* pin exp_in[3]
* pin exp_in[4]
* pin exp_in[5]
* pin exp_in[6]
* pin exp_in[7]
* pin exp_in[8]
* pin exp_in[9]
* pin exp_r[0]
* pin exp_r[10]
* pin exp_r[11]
* pin exp_r[12]
* pin exp_r[13]
* pin exp_r[14]
* pin exp_r[15]
* pin exp_r[1]
* pin exp_r[2]
* pin exp_r[3]
* pin exp_r[4]
* pin exp_r[5]
* pin exp_r[6]
* pin exp_r[7]
* pin exp_r[8]
* pin exp_r[9]
* pin j[0]
* pin j[1]
* pin j[2]
* pin j[3]
* pin j[4]
* pin mm_a[0]
* pin mm_a[10]
* pin mm_a[11]
* pin mm_a[12]
* pin mm_a[13]
* pin mm_a[14]
* pin mm_a[15]
* pin mm_a[1]
* pin mm_a[2]
* pin mm_a[3]
* pin mm_a[4]
* pin mm_a[5]
* pin mm_a[6]
* pin mm_a[7]
* pin mm_a[8]
* pin mm_a[9]
* pin mm_b[0]
* pin mm_b[10]
* pin mm_b[11]
* pin mm_b[12]
* pin mm_b[13]
* pin mm_b[14]
* pin mm_b[15]
* pin mm_b[1]
* pin mm_b[2]
* pin mm_b[3]
* pin mm_b[4]
* pin mm_b[5]
* pin mm_b[6]
* pin mm_b[7]
* pin mm_b[8]
* pin mm_b[9]
* pin mm_p[0]
* pin mm_p[10]
* pin mm_p[11]
* pin mm_p[12]
* pin mm_p[13]
* pin mm_p[14]
* pin mm_p[15]
* pin mm_p[1]
* pin mm_p[2]
* pin mm_p[3]
* pin mm_p[4]
* pin mm_p[5]
* pin mm_p[6]
* pin mm_p[7]
* pin mm_p[8]
* pin mm_p[9]
* pin mm_phase
* pin mod_in[0]
* pin mod_in[10]
* pin mod_in[11]
* pin mod_in[12]
* pin mod_in[13]
* pin mod_in[14]
* pin mod_in[15]
* pin mod_in[1]
* pin mod_in[2]
* pin mod_in[3]
* pin mod_in[4]
* pin mod_in[5]
* pin mod_in[6]
* pin mod_in[7]
* pin mod_in[8]
* pin mod_in[9]
* pin mod_r[0]
* pin mod_r[10]
* pin mod_r[11]
* pin mod_r[12]
* pin mod_r[13]
* pin mod_r[14]
* pin mod_r[15]
* pin mod_r[1]
* pin mod_r[2]
* pin mod_r[3]
* pin mod_r[4]
* pin mod_r[5]
* pin mod_r[6]
* pin mod_r[7]
* pin mod_r[8]
* pin mod_r[9]
* pin net4
* pin net5
* pin net6
* pin outer[0]
* pin outer[1]
* pin outer[2]
* pin outer[3]
* pin outer[4]
* pin result[0]
* pin result[10]
* pin result[11]
* pin result[12]
* pin result[13]
* pin result[14]
* pin result[15]
* pin result[1]
* pin result[2]
* pin result[3]
* pin result[4]
* pin result[5]
* pin result[6]
* pin result[7]
* pin result[8]
* pin result[9]
* pin rst_n
* pin start
* pin state[0]
* pin state[1]
* pin state[2]
* pin state[3]
* pin state[4]
* pin state[5]
.SUBCKT modexp VDD VSS \_0000_ \_0001_ \_0002_ \_0003_ \_0004_ \_0005_ \_0006_
+ \_0007_ \_0008_ \_0009_ \_0010_ \_0011_ \_0012_ \_0013_ \_0014_ \_0015_
+ \_0016_ \_0017_ \_0018_ \_0019_ \_0020_ \_0021_ \_0022_ \_0023_ \_0024_
+ \_0025_ \_0026_ \_0027_ \_0028_ \_0029_ \_0030_ \_0031_ \_0032_ \_0033_
+ \_0034_ \_0035_ \_0036_ \_0037_ \_0038_ \_0039_ \_0040_ \_0041_ \_0042_
+ \_0043_ \_0044_ \_0045_ \_0046_ \_0047_ \_0048_ \_0049_ \_0050_ \_0051_
+ \_0052_ \_0053_ \_0054_ \_0055_ \_0056_ \_0057_ \_0058_ \_0059_ \_0060_
+ \_0061_ \_0062_ \_0063_ \_0064_ \_0065_ \_0066_ \_0067_ \_0068_ \_0069_
+ \_0070_ \_0071_ \_0072_ \_0073_ \_0074_ \_0075_ \_0076_ \_0077_ \_0078_
+ \_0079_ \_0080_ \_0081_ \_0082_ \_0083_ \_0084_ \_0085_ \_0086_ \_0087_
+ \_0088_ \_0089_ \_0090_ \_0091_ \_0092_ \_0093_ \_0094_ \_0095_ \_0096_
+ \_0097_ \_0098_ \_0099_ \_0100_ \_0101_ \_0102_ \_0103_ \_0104_ \_0105_
+ \_0106_ \_0107_ \_0108_ \_0109_ \_0110_ \_0111_ \_0112_ \_0113_ \_0114_
+ \_0115_ \_0116_ \_0117_ \_0118_ \_0119_ \_0120_ \_0121_ \_0122_ \_0123_
+ \_0124_ \_0125_ \_0126_ \_0127_ \_0128_ \_0129_ \_0130_ \_0131_ \_0132_
+ \_0133_ \_0134_ \_0135_ \_0136_ \_0137_ \_0138_ \_0139_ \_0140_ \_0141_
+ \_0142_ \_0143_ \_0144_ \_0145_ \_0146_ \_0147_ \_0148_ \_0149_ \_0150_
+ \_0151_ \_0152_ \_0153_ \_0154_ \_0155_ \_0156_ \_0157_ \_0158_ \_0159_
+ \_0160_ \_0161_ \_0162_ \_0163_ \_0164_ \_0165_ \_0166_ \_0167_ \_0168_
+ \_0169_ \_0170_ \_0171_ \_0172_ \_0173_ \_0174_ \_0175_ \_0176_ \_0177_
+ \_0178_ \_0179_ \_0180_ \_0181_ \_0182_ \_0183_ \_0184_ \_0185_ \_0186_
+ \_0187_ \_0188_ \_0189_ \_0190_ \_0191_ \_0192_ \_0193_ \_0194_ \_0195_
+ \_0196_ \_0197_ \_0198_ \_0199_ \_0200_ \_0201_ \_0202_ \_0203_ \_0204_
+ \_0205_ \_0206_ \_0207_ \_0208_ \_0209_ \_0210_ \_0211_ \_0212_ \_0213_
+ \_0214_ \_0215_ \_0216_ \_0217_ \_0218_ \_0219_ \_0220_ \_0221_ \_0222_
+ \_0223_ \_0224_ \_0225_ \_0226_ \_0227_ \_0228_ \_0229_ \_0230_ \_0231_
+ \_0232_ \_0233_ \_0234_ \_0235_ \_0236_ \_0237_ \_0238_ \_0239_ \_0240_
+ \_0241_ \_0242_ \_0243_ \_0244_ \_0245_ \_0246_ \_0247_ \_0248_ \_0249_
+ \_0250_ \_0251_ \_0252_ \_0253_ \_0254_ \_0255_ \_0256_ \_0257_ \_0258_
+ \_0259_ \_0260_ \_0261_ \_0262_ \_0263_ \_0264_ \_0265_ \_0266_ \_0267_
+ \_0268_ \_0269_ \_0270_ \_0271_ \_0272_ \_0273_ \_0274_ \_0275_ \_0276_
+ \_0277_ \_0278_ \_0279_ \_0280_ \_0281_ \_0282_ \_0283_ \_0284_ \_0285_
+ \_0286_ \_0287_ \_0288_ \_0289_ \_0290_ \_0291_ \_0292_ \_0293_ \_0294_
+ \_0295_ \_0296_ \_0297_ \_0298_ \_0299_ \_0300_ \_0301_ \_0302_ \_0303_
+ \_0304_ \_0305_ \_0306_ \_0307_ \_0308_ \_0309_ \_0310_ \_0311_ \_0312_
+ \_0313_ \_0314_ \_0315_ \_0316_ \_0317_ \_0318_ \_0319_ \_0320_ \_0321_
+ \_0322_ \_0323_ \_0324_ \_0325_ \_0326_ \_0327_ \_0328_ \_0329_ \_0330_
+ \_0331_ \_0332_ \_0333_ \_0334_ \_0335_ \_0336_ \_0337_ \_0338_ \_0339_
+ \_0340_ \_0341_ \_0342_ \_0343_ \_0344_ \_0345_ \_0346_ \_0347_ \_0348_
+ \_0349_ \_0350_ \_0351_ \_0352_ \_0353_ \_0354_ \_0355_ \_0356_ \_0357_
+ \_0358_ \_0359_ \_0360_ \_0361_ \_0362_ \_0363_ \_0364_ \_0365_ \_0366_
+ \_0367_ \_0368_ \_0369_ \_0370_ \_0371_ \_0372_ \_0373_ \_0374_ \_0375_
+ \_0376_ \_0377_ \_0378_ \_0379_ \_0380_ \_0381_ \_0382_ \_0383_ \_0384_
+ \_0385_ \_0386_ \_0387_ \_0388_ \_0389_ \_0390_ \_0391_ \_0392_ \_0393_
+ \_0394_ \_0395_ \_0396_ \_0397_ \_0398_ \_0399_ \_0400_ \_0401_ \_0402_
+ \_0403_ \_0404_ \_0405_ \_0406_ \_0407_ \_0408_ \_0409_ \_0410_ \_0411_
+ \_0412_ \_0413_ \_0414_ \_0415_ \_0416_ \_0417_ \_0418_ \_0419_ \_0420_
+ \_0421_ \_0422_ \_0423_ \_0424_ \_0425_ \_0426_ \_0427_ \_0428_ \_0429_
+ \_0430_ \_0431_ \_0432_ \_0433_ \_0434_ \_0435_ \_0436_ \_0437_ \_0438_
+ \_0439_ \_0440_ \_0441_ \_0442_ \_0443_ \_0444_ \_0445_ \_0446_ \_0447_
+ \_0448_ \_0449_ \_0450_ \_0451_ \_0452_ \_0453_ \_0454_ \_0455_ \_0456_
+ \_0457_ \_0458_ \_0459_ \_0460_ \_0461_ \_0462_ \_0463_ \_0464_ \_0465_
+ \_0466_ \_0467_ \_0468_ \_0469_ \_0470_ \_0471_ \_0472_ \_0473_ \_0474_
+ \_0475_ \_0476_ \_0477_ \_0478_ \_0479_ \_0480_ \_0481_ \_0482_ \_0483_
+ \_0484_ \_0485_ \_0486_ \_0487_ \_0488_ \_0489_ \_0490_ \_0491_ \_0492_
+ \_0493_ \_0494_ \_0495_ \_0496_ \_0497_ \_0498_ \_0499_ \_0500_ \_0501_
+ \_0502_ \_0503_ \_0504_ \_0505_ \_0506_ \_0507_ \_0508_ \_0509_ \_0510_
+ \_0511_ \_0512_ \_0513_ \_0514_ \_0515_ \_0516_ \_0517_ \_0518_ \_0519_
+ \_0520_ \_0521_ \_0522_ \_0523_ \_0524_ \_0525_ \_0526_ \_0527_ \_0528_
+ \_0529_ \_0530_ \_0531_ \_0532_ \_0533_ \_0534_ \_0535_ \_0536_ \_0537_
+ \_0538_ \_0539_ \_0540_ \_0541_ \_0542_ \_0543_ \_0544_ \_0545_ \_0546_
+ \_0547_ \_0548_ \_0549_ \_0550_ \_0551_ \_tie_zero_ base_in[0] base_in[10]
+ base_in[11] base_in[12] base_in[13] base_in[14] base_in[15] base_in[1]
+ base_in[2] base_in[3] base_in[4] base_in[5] base_in[6] base_in[7] base_in[8]
+ base_in[9] base_r[0] base_r[10] base_r[11] base_r[12] base_r[13] base_r[14]
+ base_r[15] base_r[1] base_r[2] base_r[3] base_r[4] base_r[5] base_r[6]
+ base_r[7] base_r[8] base_r[9] clk clknet_0_clk clknet_4_0_0_clk
+ clknet_4_10_0_clk clknet_4_11_0_clk clknet_4_12_0_clk clknet_4_13_0_clk
+ clknet_4_14_0_clk clknet_4_15_0_clk clknet_4_1_0_clk clknet_4_2_0_clk
+ clknet_4_3_0_clk clknet_4_4_0_clk clknet_4_5_0_clk clknet_4_6_0_clk
+ clknet_4_7_0_clk clknet_4_8_0_clk clknet_4_9_0_clk done exp_in[0] exp_in[10]
+ exp_in[11] exp_in[12] exp_in[13] exp_in[14] exp_in[15] exp_in[1] exp_in[2]
+ exp_in[3] exp_in[4] exp_in[5] exp_in[6] exp_in[7] exp_in[8] exp_in[9]
+ exp_r[0] exp_r[10] exp_r[11] exp_r[12] exp_r[13] exp_r[14] exp_r[15] exp_r[1]
+ exp_r[2] exp_r[3] exp_r[4] exp_r[5] exp_r[6] exp_r[7] exp_r[8] exp_r[9] j[0]
+ j[1] j[2] j[3] j[4] mm_a[0] mm_a[10] mm_a[11] mm_a[12] mm_a[13] mm_a[14]
+ mm_a[15] mm_a[1] mm_a[2] mm_a[3] mm_a[4] mm_a[5] mm_a[6] mm_a[7] mm_a[8]
+ mm_a[9] mm_b[0] mm_b[10] mm_b[11] mm_b[12] mm_b[13] mm_b[14] mm_b[15] mm_b[1]
+ mm_b[2] mm_b[3] mm_b[4] mm_b[5] mm_b[6] mm_b[7] mm_b[8] mm_b[9] mm_p[0]
+ mm_p[10] mm_p[11] mm_p[12] mm_p[13] mm_p[14] mm_p[15] mm_p[1] mm_p[2] mm_p[3]
+ mm_p[4] mm_p[5] mm_p[6] mm_p[7] mm_p[8] mm_p[9] mm_phase mod_in[0] mod_in[10]
+ mod_in[11] mod_in[12] mod_in[13] mod_in[14] mod_in[15] mod_in[1] mod_in[2]
+ mod_in[3] mod_in[4] mod_in[5] mod_in[6] mod_in[7] mod_in[8] mod_in[9]
+ mod_r[0] mod_r[10] mod_r[11] mod_r[12] mod_r[13] mod_r[14] mod_r[15] mod_r[1]
+ mod_r[2] mod_r[3] mod_r[4] mod_r[5] mod_r[6] mod_r[7] mod_r[8] mod_r[9] net4
+ net5 net6 outer[0] outer[1] outer[2] outer[3] outer[4] result[0] result[10]
+ result[11] result[12] result[13] result[14] result[15] result[1] result[2]
+ result[3] result[4] result[5] result[6] result[7] result[8] result[9] rst_n
+ start state[0] state[1] state[2] state[3] state[4] state[5]
* cell instance sky130_fd_sc_hd__a211o_1_0 r0 *1 0,0
Xsky130_fd_sc_hd__a211o_1_0 \_0202_ \_0204_ \_0195_ \_0197_ VSS VDD VDD \_0206_
+ sky130_fd_sc_hd__a211o_1
* cell instance sky130_fd_sc_hd__a211o_1_1 r0 *1 0,0
Xsky130_fd_sc_hd__a211o_1_1 \_0247_ \_0264_ \_0248_ \_0244_ VSS VDD VDD \_0266_
+ sky130_fd_sc_hd__a211o_1
* cell instance sky130_fd_sc_hd__a211oi_1_0 r0 *1 0,0
Xsky130_fd_sc_hd__a211oi_1_0 \_0344_ \_0423_ \_0424_ \_0289_ VSS VDD VDD
+ \_0425_ sky130_fd_sc_hd__a211oi_1
* cell instance sky130_fd_sc_hd__a211oi_1_1 r0 *1 0,0
Xsky130_fd_sc_hd__a211oi_1_1 \_0344_ \_0410_ \_0411_ \_0289_ VSS VDD VDD
+ \_0412_ sky130_fd_sc_hd__a211oi_1
* cell instance sky130_fd_sc_hd__a211oi_1_2 r0 *1 0,0
Xsky130_fd_sc_hd__a211oi_1_2 \_0344_ \_0367_ \_0368_ \_0289_ VSS VDD VDD
+ \_0369_ sky130_fd_sc_hd__a211oi_1
* cell instance sky130_fd_sc_hd__a211oi_1_3 r0 *1 0,0
Xsky130_fd_sc_hd__a211oi_1_3 \_0233_ \_0275_ \_0274_ \_0235_ VSS VDD VDD
+ \_0370_ sky130_fd_sc_hd__a211oi_1
* cell instance sky130_fd_sc_hd__a211oi_1_4 r0 *1 0,0
Xsky130_fd_sc_hd__a211oi_1_4 \_0176_ \_0214_ \_0173_ \_0174_ VSS VDD VDD
+ \_0216_ sky130_fd_sc_hd__a211oi_1
* cell instance sky130_fd_sc_hd__a21boi_0_0 r0 *1 0,0
Xsky130_fd_sc_hd__a21boi_0_0 \_0131_ exp_r[15] state[5] VSS VDD VDD \_0003_
+ sky130_fd_sc_hd__a21boi_0
* cell instance sky130_fd_sc_hd__a21boi_0_1 r0 *1 0,0
Xsky130_fd_sc_hd__a21boi_0_1 \_0200_ \_0256_ mod_r[0] VSS VDD VDD \_0258_
+ sky130_fd_sc_hd__a21boi_0
* cell instance sky130_fd_sc_hd__a21o_1_0 r0 *1 0,0
Xsky130_fd_sc_hd__a21o_1_0 mm_a[15] mm_b[1] mm_p[0] VSS VDD VDD \_0256_
+ sky130_fd_sc_hd__a21o_1
* cell instance sky130_fd_sc_hd__a21o_1_1 r0 *1 0,0
Xsky130_fd_sc_hd__a21o_1_1 mm_a[15] mm_b[4] mm_p[3] VSS VDD VDD \_0196_
+ sky130_fd_sc_hd__a21o_1
* cell instance sky130_fd_sc_hd__a21o_1_2 r0 *1 0,0
Xsky130_fd_sc_hd__a21o_1_2 \_0202_ \_0204_ \_0197_ VSS VDD VDD \_0205_
+ sky130_fd_sc_hd__a21o_1
* cell instance sky130_fd_sc_hd__a21o_1_3 r0 *1 0,0
Xsky130_fd_sc_hd__a21o_1_3 \_0243_ \_0266_ \_0268_ VSS VDD VDD \_0269_
+ sky130_fd_sc_hd__a21o_1
* cell instance sky130_fd_sc_hd__a21o_1_4 r0 *1 0,0
Xsky130_fd_sc_hd__a21o_1_4 mm_a[15] mm_b[13] mm_p[12] VSS VDD VDD \_0170_
+ sky130_fd_sc_hd__a21o_1
* cell instance sky130_fd_sc_hd__a21o_1_5 r0 *1 0,0
Xsky130_fd_sc_hd__a21o_1_5 mm_b[14] mm_a[15] mm_p[13] VSS VDD VDD \_0168_
+ sky130_fd_sc_hd__a21o_1
* cell instance sky130_fd_sc_hd__a21o_1_6 r0 *1 0,0
Xsky130_fd_sc_hd__a21o_1_6 mm_a[15] mm_b[15] mm_p[14] VSS VDD VDD \_0165_
+ sky130_fd_sc_hd__a21o_1
* cell instance sky130_fd_sc_hd__a21oi_1_0 r0 *1 0,0
Xsky130_fd_sc_hd__a21oi_1_0 \_0129_ \_0531_ \_0132_ VSS VDD VDD \_0541_
+ sky130_fd_sc_hd__a21oi_1
* cell instance sky130_fd_sc_hd__a21oi_1_1 r0 *1 0,0
Xsky130_fd_sc_hd__a21oi_1_1 j[0] \_0159_ \_0162_ VSS VDD VDD \_0017_
+ sky130_fd_sc_hd__a21oi_1
* cell instance sky130_fd_sc_hd__a21oi_1_2 r0 *1 0,0
Xsky130_fd_sc_hd__a21oi_1_2 \_0131_ \_0512_ \_0510_ VSS VDD VDD \_0105_
+ sky130_fd_sc_hd__a21oi_1
* cell instance sky130_fd_sc_hd__a21oi_1_3 r0 *1 0,0
Xsky130_fd_sc_hd__a21oi_1_3 \_0130_ net5 \_0441_ VSS VDD VDD \_0047_
+ sky130_fd_sc_hd__a21oi_1
* cell instance sky130_fd_sc_hd__a21oi_1_4 r0 *1 0,0
Xsky130_fd_sc_hd__a21oi_1_4 mm_phase base_r[0] \_0497_ VSS VDD VDD \_0498_
+ sky130_fd_sc_hd__a21oi_1
* cell instance sky130_fd_sc_hd__a21oi_1_5 r0 *1 0,0
Xsky130_fd_sc_hd__a21oi_1_5 mm_a[15] mm_b[2] mm_p[1] VSS VDD VDD \_0201_
+ sky130_fd_sc_hd__a21oi_1
* cell instance sky130_fd_sc_hd__a21oi_1_6 r0 *1 0,0
Xsky130_fd_sc_hd__a21oi_1_6 mm_a[15] mm_b[3] mm_p[2] VSS VDD VDD \_0203_
+ sky130_fd_sc_hd__a21oi_1
* cell instance sky130_fd_sc_hd__a21oi_1_7 r0 *1 0,0
Xsky130_fd_sc_hd__a21oi_1_7 \_0196_ \_0206_ \_0194_ VSS VDD VDD \_0249_
+ sky130_fd_sc_hd__a21oi_1
* cell instance sky130_fd_sc_hd__a21oi_1_8 r0 *1 0,0
Xsky130_fd_sc_hd__a21oi_1_8 mm_a[15] mm_b[5] mm_p[4] VSS VDD VDD \_0193_
+ sky130_fd_sc_hd__a21oi_1
* cell instance sky130_fd_sc_hd__a21oi_1_9 r0 *1 0,0
Xsky130_fd_sc_hd__a21oi_1_9 mm_a[15] mm_b[6] mm_p[5] VSS VDD VDD \_0190_
+ sky130_fd_sc_hd__a21oi_1
* cell instance sky130_fd_sc_hd__a21oi_1_10 r0 *1 0,0
Xsky130_fd_sc_hd__a21oi_1_10 \_0247_ \_0264_ \_0248_ VSS VDD VDD \_0265_
+ sky130_fd_sc_hd__a21oi_1
* cell instance sky130_fd_sc_hd__a21oi_1_11 r0 *1 0,0
Xsky130_fd_sc_hd__a21oi_1_11 \_0303_ \_0323_ \_0324_ VSS VDD VDD \_0325_
+ sky130_fd_sc_hd__a21oi_1
* cell instance sky130_fd_sc_hd__a21oi_1_12 r0 *1 0,0
Xsky130_fd_sc_hd__a21oi_1_12 mm_a[15] mm_b[7] mm_p[6] VSS VDD VDD \_0187_
+ sky130_fd_sc_hd__a21oi_1
* cell instance sky130_fd_sc_hd__a21oi_1_13 r0 *1 0,0
Xsky130_fd_sc_hd__a21oi_1_13 \_0241_ \_0269_ \_0270_ VSS VDD VDD \_0271_
+ sky130_fd_sc_hd__a21oi_1
* cell instance sky130_fd_sc_hd__a21oi_1_14 r0 *1 0,0
Xsky130_fd_sc_hd__a21oi_1_14 \_0297_ \_0329_ \_0298_ VSS VDD VDD \_0330_
+ sky130_fd_sc_hd__a21oi_1
* cell instance sky130_fd_sc_hd__a21oi_1_15 r0 *1 0,0
Xsky130_fd_sc_hd__a21oi_1_15 mm_a[15] mm_b[11] mm_p[10] VSS VDD VDD \_0175_
+ sky130_fd_sc_hd__a21oi_1
* cell instance sky130_fd_sc_hd__a21oi_1_16 r0 *1 0,0
Xsky130_fd_sc_hd__a21oi_1_16 \_0176_ \_0214_ \_0174_ VSS VDD VDD \_0215_
+ sky130_fd_sc_hd__a21oi_1
* cell instance sky130_fd_sc_hd__a21oi_1_17 r0 *1 0,0
Xsky130_fd_sc_hd__a21oi_1_17 mm_a[15] mm_b[12] mm_p[11] VSS VDD VDD \_0172_
+ sky130_fd_sc_hd__a21oi_1
* cell instance sky130_fd_sc_hd__a21oi_1_18 r0 *1 0,0
Xsky130_fd_sc_hd__a21oi_1_18 \_0233_ \_0276_ \_0277_ VSS VDD VDD \_0278_
+ sky130_fd_sc_hd__a21oi_1
* cell instance sky130_fd_sc_hd__a21oi_1_19 r0 *1 0,0
Xsky130_fd_sc_hd__a21oi_1_19 \_0292_ \_0338_ \_0339_ VSS VDD VDD \_0340_
+ sky130_fd_sc_hd__a21oi_1
* cell instance sky130_fd_sc_hd__a21oi_1_20 r0 *1 0,0
Xsky130_fd_sc_hd__a21oi_1_20 \_0226_ \_0282_ \_0284_ VSS VDD VDD \_0285_
+ sky130_fd_sc_hd__a21oi_1
* cell instance sky130_fd_sc_hd__a222oi_1_0 r0 *1 0,0
Xsky130_fd_sc_hd__a222oi_1_0 state[2] mm_a[0] \_0140_ mm_a[1] \_0145_ result[1]
+ VSS VDD VDD \_0153_ sky130_fd_sc_hd__a222oi_1
* cell instance sky130_fd_sc_hd__a222oi_1_1 r0 *1 0,0
Xsky130_fd_sc_hd__a222oi_1_1 state[2] mm_a[1] \_0140_ mm_a[2] \_0145_ result[2]
+ VSS VDD VDD \_0152_ sky130_fd_sc_hd__a222oi_1
* cell instance sky130_fd_sc_hd__a222oi_1_2 r0 *1 0,0
Xsky130_fd_sc_hd__a222oi_1_2 state[2] mm_a[2] \_0140_ mm_a[3] \_0145_ result[3]
+ VSS VDD VDD \_0151_ sky130_fd_sc_hd__a222oi_1
* cell instance sky130_fd_sc_hd__a222oi_1_3 r0 *1 0,0
Xsky130_fd_sc_hd__a222oi_1_3 state[2] mm_a[3] \_0140_ mm_a[4] \_0145_ result[4]
+ VSS VDD VDD \_0150_ sky130_fd_sc_hd__a222oi_1
* cell instance sky130_fd_sc_hd__a222oi_1_4 r0 *1 0,0
Xsky130_fd_sc_hd__a222oi_1_4 state[2] mm_a[4] \_0140_ mm_a[5] \_0145_ result[5]
+ VSS VDD VDD \_0149_ sky130_fd_sc_hd__a222oi_1
* cell instance sky130_fd_sc_hd__a222oi_1_5 r0 *1 0,0
Xsky130_fd_sc_hd__a222oi_1_5 state[2] mm_a[5] \_0140_ mm_a[6] \_0145_ result[6]
+ VSS VDD VDD \_0148_ sky130_fd_sc_hd__a222oi_1
* cell instance sky130_fd_sc_hd__a222oi_1_6 r0 *1 0,0
Xsky130_fd_sc_hd__a222oi_1_6 state[2] mm_a[6] \_0140_ mm_a[7] \_0145_ result[7]
+ VSS VDD VDD \_0147_ sky130_fd_sc_hd__a222oi_1
* cell instance sky130_fd_sc_hd__a222oi_1_7 r0 *1 0,0
Xsky130_fd_sc_hd__a222oi_1_7 state[2] mm_a[7] \_0140_ mm_a[8] \_0145_ result[8]
+ VSS VDD VDD \_0551_ sky130_fd_sc_hd__a222oi_1
* cell instance sky130_fd_sc_hd__a222oi_1_8 r0 *1 0,0
Xsky130_fd_sc_hd__a222oi_1_8 state[2] mm_a[14] \_0140_ mm_a[15] \_0145_
+ result[15] VSS VDD VDD \_0536_ sky130_fd_sc_hd__a222oi_1
* cell instance sky130_fd_sc_hd__a222oi_1_9 r0 *1 0,0
Xsky130_fd_sc_hd__a222oi_1_9 state[2] mm_a[8] \_0140_ mm_a[9] \_0145_ result[9]
+ VSS VDD VDD \_0550_ sky130_fd_sc_hd__a222oi_1
* cell instance sky130_fd_sc_hd__a222oi_1_10 r0 *1 0,0
Xsky130_fd_sc_hd__a222oi_1_10 state[2] mm_a[9] \_0140_ mm_a[10] \_0145_
+ result[10] VSS VDD VDD \_0549_ sky130_fd_sc_hd__a222oi_1
* cell instance sky130_fd_sc_hd__a222oi_1_11 r0 *1 0,0
Xsky130_fd_sc_hd__a222oi_1_11 state[2] mm_a[10] \_0140_ mm_a[11] \_0145_
+ result[11] VSS VDD VDD \_0548_ sky130_fd_sc_hd__a222oi_1
* cell instance sky130_fd_sc_hd__a222oi_1_12 r0 *1 0,0
Xsky130_fd_sc_hd__a222oi_1_12 mm_a[13] state[2] mm_a[14] \_0140_ \_0145_
+ result[14] VSS VDD VDD \_0545_ sky130_fd_sc_hd__a222oi_1
* cell instance sky130_fd_sc_hd__a222oi_1_13 r0 *1 0,0
Xsky130_fd_sc_hd__a222oi_1_13 state[2] mm_a[12] \_0145_ result[13] \_0140_
+ mm_a[13] VSS VDD VDD \_0546_ sky130_fd_sc_hd__a222oi_1
* cell instance sky130_fd_sc_hd__a222oi_1_14 r0 *1 0,0
Xsky130_fd_sc_hd__a222oi_1_14 state[2] mm_a[11] \_0140_ mm_a[12] \_0145_
+ result[12] VSS VDD VDD \_0547_ sky130_fd_sc_hd__a222oi_1
* cell instance sky130_fd_sc_hd__a22o_1_0 r0 *1 0,0
Xsky130_fd_sc_hd__a22o_1_0 exp_r[0] \_0442_ \_0529_ exp_in[0] VSS VDD VDD
+ \_0113_ sky130_fd_sc_hd__a22o_1
* cell instance sky130_fd_sc_hd__a22o_1_1 r0 *1 0,0
Xsky130_fd_sc_hd__a22o_1_1 result[1] net5 \_0439_ mm_p[1] VSS VDD VDD \_0046_
+ sky130_fd_sc_hd__a22o_1
* cell instance sky130_fd_sc_hd__a22o_1_2 r0 *1 0,0
Xsky130_fd_sc_hd__a22o_1_2 result[2] net5 \_0439_ mm_p[2] VSS VDD VDD \_0045_
+ sky130_fd_sc_hd__a22o_1
* cell instance sky130_fd_sc_hd__a22o_1_3 r0 *1 0,0
Xsky130_fd_sc_hd__a22o_1_3 result[5] net5 \_0439_ mm_p[5] VSS VDD VDD \_0042_
+ sky130_fd_sc_hd__a22o_1
* cell instance sky130_fd_sc_hd__a22o_1_4 r0 *1 0,0
Xsky130_fd_sc_hd__a22o_1_4 result[3] net5 \_0439_ mm_p[3] VSS VDD VDD \_0044_
+ sky130_fd_sc_hd__a22o_1
* cell instance sky130_fd_sc_hd__a22o_1_5 r0 *1 0,0
Xsky130_fd_sc_hd__a22o_1_5 result[4] net5 \_0439_ mm_p[4] VSS VDD VDD \_0043_
+ sky130_fd_sc_hd__a22o_1
* cell instance sky130_fd_sc_hd__a22o_1_6 r0 *1 0,0
Xsky130_fd_sc_hd__a22o_1_6 result[6] net5 \_0439_ mm_p[6] VSS VDD VDD \_0041_
+ sky130_fd_sc_hd__a22o_1
* cell instance sky130_fd_sc_hd__a22o_1_7 r0 *1 0,0
Xsky130_fd_sc_hd__a22o_1_7 result[7] net5 \_0439_ mm_p[7] VSS VDD VDD \_0040_
+ sky130_fd_sc_hd__a22o_1
* cell instance sky130_fd_sc_hd__a22o_1_8 r0 *1 0,0
Xsky130_fd_sc_hd__a22o_1_8 result[8] net5 \_0439_ mm_p[8] VSS VDD VDD \_0039_
+ sky130_fd_sc_hd__a22o_1
* cell instance sky130_fd_sc_hd__a22o_1_9 r0 *1 0,0
Xsky130_fd_sc_hd__a22o_1_9 result[9] net5 \_0439_ mm_p[9] VSS VDD VDD \_0038_
+ sky130_fd_sc_hd__a22o_1
* cell instance sky130_fd_sc_hd__a22o_1_10 r0 *1 0,0
Xsky130_fd_sc_hd__a22o_1_10 result[10] net5 \_0439_ mm_p[10] VSS VDD VDD
+ \_0037_ sky130_fd_sc_hd__a22o_1
* cell instance sky130_fd_sc_hd__a22o_1_11 r0 *1 0,0
Xsky130_fd_sc_hd__a22o_1_11 result[11] net5 \_0439_ mm_p[11] VSS VDD VDD
+ \_0036_ sky130_fd_sc_hd__a22o_1
* cell instance sky130_fd_sc_hd__a22o_1_12 r0 *1 0,0
Xsky130_fd_sc_hd__a22o_1_12 result[14] net5 \_0439_ mm_p[14] VSS VDD VDD
+ \_0033_ sky130_fd_sc_hd__a22o_1
* cell instance sky130_fd_sc_hd__a22o_1_13 r0 *1 0,0
Xsky130_fd_sc_hd__a22o_1_13 result[13] net5 \_0439_ mm_p[13] VSS VDD VDD
+ \_0034_ sky130_fd_sc_hd__a22o_1
* cell instance sky130_fd_sc_hd__a22o_1_14 r0 *1 0,0
Xsky130_fd_sc_hd__a22o_1_14 result[15] net5 \_0439_ mm_p[15] VSS VDD VDD
+ \_0108_ sky130_fd_sc_hd__a22o_1
* cell instance sky130_fd_sc_hd__a22o_1_15 r0 *1 0,0
Xsky130_fd_sc_hd__a22o_1_15 result[12] net5 \_0439_ mm_p[12] VSS VDD VDD
+ \_0035_ sky130_fd_sc_hd__a22o_1
* cell instance sky130_fd_sc_hd__a311o_1_0 r0 *1 0,0
Xsky130_fd_sc_hd__a311o_1_0 \_0194_ \_0196_ \_0206_ \_0192_ \_0189_ VSS VDD VDD
+ \_0209_ sky130_fd_sc_hd__a311o_1
* cell instance sky130_fd_sc_hd__a311oi_1_0 r0 *1 0,0
Xsky130_fd_sc_hd__a311oi_1_0 \_0328_ \_0344_ \_0387_ \_0388_ \_0289_ VSS VDD
+ VDD \_0390_ sky130_fd_sc_hd__a311oi_1
* cell instance sky130_fd_sc_hd__a311oi_1_1 r0 *1 0,0
Xsky130_fd_sc_hd__a311oi_1_1 \_0297_ \_0301_ \_0328_ \_0298_ \_0296_ VSS VDD
+ VDD \_0331_ sky130_fd_sc_hd__a311oi_1
* cell instance sky130_fd_sc_hd__a31o_1_0 r0 *1 0,0
Xsky130_fd_sc_hd__a31o_1_0 \_0188_ \_0191_ \_0209_ \_0186_ VSS VDD VDD \_0211_
+ sky130_fd_sc_hd__a31o_1
* cell instance sky130_fd_sc_hd__a31oi_1_0 r0 *1 0,0
Xsky130_fd_sc_hd__a31oi_1_0 state[3] \_0493_ \_0494_ \_0495_ VSS VDD VDD
+ \_0097_ sky130_fd_sc_hd__a31oi_1
* cell instance sky130_fd_sc_hd__a31oi_1_1 r0 *1 0,0
Xsky130_fd_sc_hd__a31oi_1_1 state[3] \_0490_ \_0491_ \_0492_ VSS VDD VDD
+ \_0096_ sky130_fd_sc_hd__a31oi_1
* cell instance sky130_fd_sc_hd__a31oi_1_2 r0 *1 0,0
Xsky130_fd_sc_hd__a31oi_1_2 state[3] \_0484_ \_0485_ \_0486_ VSS VDD VDD
+ \_0094_ sky130_fd_sc_hd__a31oi_1
* cell instance sky130_fd_sc_hd__a31oi_1_3 r0 *1 0,0
Xsky130_fd_sc_hd__a31oi_1_3 state[3] \_0487_ \_0488_ \_0489_ VSS VDD VDD
+ \_0095_ sky130_fd_sc_hd__a31oi_1
* cell instance sky130_fd_sc_hd__a31oi_1_4 r0 *1 0,0
Xsky130_fd_sc_hd__a31oi_1_4 state[3] \_0481_ \_0482_ \_0483_ VSS VDD VDD
+ \_0093_ sky130_fd_sc_hd__a31oi_1
* cell instance sky130_fd_sc_hd__a31oi_1_5 r0 *1 0,0
Xsky130_fd_sc_hd__a31oi_1_5 state[3] \_0478_ \_0479_ \_0480_ VSS VDD VDD
+ \_0092_ sky130_fd_sc_hd__a31oi_1
* cell instance sky130_fd_sc_hd__a31oi_1_6 r0 *1 0,0
Xsky130_fd_sc_hd__a31oi_1_6 \_0194_ \_0196_ \_0206_ \_0192_ VSS VDD VDD \_0208_
+ sky130_fd_sc_hd__a31oi_1
* cell instance sky130_fd_sc_hd__a31oi_1_7 r0 *1 0,0
Xsky130_fd_sc_hd__a31oi_1_7 state[3] \_0475_ \_0476_ \_0477_ VSS VDD VDD
+ \_0091_ sky130_fd_sc_hd__a31oi_1
* cell instance sky130_fd_sc_hd__a31oi_1_8 r0 *1 0,0
Xsky130_fd_sc_hd__a31oi_1_8 state[3] \_0469_ \_0470_ \_0471_ VSS VDD VDD
+ \_0088_ sky130_fd_sc_hd__a31oi_1
* cell instance sky130_fd_sc_hd__a31oi_1_9 r0 *1 0,0
Xsky130_fd_sc_hd__a31oi_1_9 state[3] \_0463_ \_0464_ \_0465_ VSS VDD VDD
+ \_0086_ sky130_fd_sc_hd__a31oi_1
* cell instance sky130_fd_sc_hd__a31oi_1_10 r0 *1 0,0
Xsky130_fd_sc_hd__a31oi_1_10 state[3] \_0472_ \_0473_ \_0474_ VSS VDD VDD
+ \_0090_ sky130_fd_sc_hd__a31oi_1
* cell instance sky130_fd_sc_hd__a31oi_1_11 r0 *1 0,0
Xsky130_fd_sc_hd__a31oi_1_11 state[3] \_0457_ \_0458_ \_0459_ VSS VDD VDD
+ \_0084_ sky130_fd_sc_hd__a31oi_1
* cell instance sky130_fd_sc_hd__a31oi_1_12 r0 *1 0,0
Xsky130_fd_sc_hd__a31oi_1_12 state[3] \_0460_ \_0461_ \_0462_ VSS VDD VDD
+ \_0085_ sky130_fd_sc_hd__a31oi_1
* cell instance sky130_fd_sc_hd__a31oi_1_13 r0 *1 0,0
Xsky130_fd_sc_hd__a31oi_1_13 state[3] \_0454_ \_0455_ \_0456_ VSS VDD VDD
+ \_0083_ sky130_fd_sc_hd__a31oi_1
* cell instance sky130_fd_sc_hd__a31oi_1_14 r0 *1 0,0
Xsky130_fd_sc_hd__a31oi_1_14 state[3] \_0451_ \_0452_ \_0453_ VSS VDD VDD
+ \_0082_ sky130_fd_sc_hd__a31oi_1
* cell instance sky130_fd_sc_hd__a31oi_1_15 r0 *1 0,0
Xsky130_fd_sc_hd__a31oi_1_15 state[3] \_0466_ \_0467_ \_0468_ VSS VDD VDD
+ \_0087_ sky130_fd_sc_hd__a31oi_1
* cell instance sky130_fd_sc_hd__a31oi_1_16 r0 *1 0,0
Xsky130_fd_sc_hd__a31oi_1_16 \_0223_ \_0341_ \_0342_ \_0343_ VSS VDD VDD
+ \_0519_ sky130_fd_sc_hd__a31oi_1
* cell instance sky130_fd_sc_hd__a32o_1_0 r0 *1 0,0
Xsky130_fd_sc_hd__a32o_1_0 state[2] \_0137_ \_0161_ \_0140_ j[1] VSS VDD VDD
+ \_0016_ sky130_fd_sc_hd__a32o_1
* cell instance sky130_fd_sc_hd__a32o_1_1 r0 *1 0,0
Xsky130_fd_sc_hd__a32o_1_1 state[2] \_0420_ \_0421_ \_0140_ mm_p[3] VSS VDD VDD
+ \_0029_ sky130_fd_sc_hd__a32o_1
* cell instance sky130_fd_sc_hd__a32o_1_2 r0 *1 0,0
Xsky130_fd_sc_hd__a32o_1_2 state[2] \_0407_ \_0408_ \_0140_ mm_p[5] VSS VDD VDD
+ \_0027_ sky130_fd_sc_hd__a32o_1
* cell instance sky130_fd_sc_hd__a32o_1_3 r0 *1 0,0
Xsky130_fd_sc_hd__a32o_1_3 state[2] \_0399_ \_0402_ \_0140_ mm_p[6] VSS VDD VDD
+ \_0026_ sky130_fd_sc_hd__a32o_1
* cell instance sky130_fd_sc_hd__a32o_1_4 r0 *1 0,0
Xsky130_fd_sc_hd__a32o_1_4 state[2] \_0395_ \_0396_ \_0140_ mm_p[7] VSS VDD VDD
+ \_0025_ sky130_fd_sc_hd__a32o_1
* cell instance sky130_fd_sc_hd__a32o_1_5 r0 *1 0,0
Xsky130_fd_sc_hd__a32o_1_5 state[2] \_0384_ \_0385_ \_0140_ mm_p[9] VSS VDD VDD
+ \_0023_ sky130_fd_sc_hd__a32o_1
* cell instance sky130_fd_sc_hd__a32o_1_6 r0 *1 0,0
Xsky130_fd_sc_hd__a32o_1_6 state[2] \_0375_ \_0377_ \_0140_ mm_p[10] VSS VDD
+ VDD \_0022_ sky130_fd_sc_hd__a32o_1
* cell instance sky130_fd_sc_hd__a32o_1_7 r0 *1 0,0
Xsky130_fd_sc_hd__a32o_1_7 state[2] \_0361_ \_0364_ \_0140_ mm_p[12] VSS VDD
+ VDD \_0020_ sky130_fd_sc_hd__a32o_1
* cell instance sky130_fd_sc_hd__a32o_1_8 r0 *1 0,0
Xsky130_fd_sc_hd__a32o_1_8 state[2] \_0521_ \_0524_ mm_p[15] \_0140_ VSS VDD
+ VDD \_0110_ sky130_fd_sc_hd__a32o_1
* cell instance sky130_fd_sc_hd__and2_0_0 r0 *1 0,0
Xsky130_fd_sc_hd__and2_0_0 state[5] \_0144_ VSS VDD VDD \_0439_
+ sky130_fd_sc_hd__and2_0
* cell instance sky130_fd_sc_hd__and2_0_1 r0 *1 0,0
Xsky130_fd_sc_hd__and2_0_1 mod_r[0] \_0312_ VSS VDD VDD \_0313_
+ sky130_fd_sc_hd__and2_0
* cell instance sky130_fd_sc_hd__and2_0_2 r0 *1 0,0
Xsky130_fd_sc_hd__and2_0_2 \_0243_ \_0266_ VSS VDD VDD \_0267_
+ sky130_fd_sc_hd__and2_0
* cell instance sky130_fd_sc_hd__and2_0_3 r0 *1 0,0
Xsky130_fd_sc_hd__and2_0_3 \_0301_ \_0328_ VSS VDD VDD \_0329_
+ sky130_fd_sc_hd__and2_0
* cell instance sky130_fd_sc_hd__and2_0_4 r0 *1 0,0
Xsky130_fd_sc_hd__and2_0_4 mod_r[9] \_0237_ VSS VDD VDD \_0298_
+ sky130_fd_sc_hd__and2_0
* cell instance sky130_fd_sc_hd__and2_0_5 r0 *1 0,0
Xsky130_fd_sc_hd__and2_0_5 mod_r[15] \_0221_ VSS VDD VDD \_0222_
+ sky130_fd_sc_hd__and2_0
* cell instance sky130_fd_sc_hd__and3_1_0 r0 *1 0,0
Xsky130_fd_sc_hd__and3_1_0 mm_p[3] mm_a[15] mm_b[4] VSS VDD VDD \_0195_
+ sky130_fd_sc_hd__and3_1
* cell instance sky130_fd_sc_hd__and3_1_1 r0 *1 0,0
Xsky130_fd_sc_hd__and3_1_1 mm_p[2] mm_a[15] mm_b[3] VSS VDD VDD \_0197_
+ sky130_fd_sc_hd__and3_1
* cell instance sky130_fd_sc_hd__and3_1_2 r0 *1 0,0
Xsky130_fd_sc_hd__and3_1_2 \_0194_ \_0196_ \_0206_ VSS VDD VDD \_0207_
+ sky130_fd_sc_hd__and3_1
* cell instance sky130_fd_sc_hd__and3_1_3 r0 *1 0,0
Xsky130_fd_sc_hd__and3_1_3 mm_p[4] mm_a[15] mm_b[5] VSS VDD VDD \_0192_
+ sky130_fd_sc_hd__and3_1
* cell instance sky130_fd_sc_hd__and3_1_4 r0 *1 0,0
Xsky130_fd_sc_hd__and3_1_4 mm_p[5] mm_a[15] mm_b[6] VSS VDD VDD \_0189_
+ sky130_fd_sc_hd__and3_1
* cell instance sky130_fd_sc_hd__and3_1_5 r0 *1 0,0
Xsky130_fd_sc_hd__and3_1_5 mm_p[6] mm_a[15] mm_b[7] VSS VDD VDD \_0186_
+ sky130_fd_sc_hd__and3_1
* cell instance sky130_fd_sc_hd__and3_1_6 r0 *1 0,0
Xsky130_fd_sc_hd__and3_1_6 mm_p[10] mm_a[15] mm_b[11] VSS VDD VDD \_0174_
+ sky130_fd_sc_hd__and3_1
* cell instance sky130_fd_sc_hd__and3_1_7 r0 *1 0,0
Xsky130_fd_sc_hd__and3_1_7 mm_p[11] mm_a[15] mm_b[12] VSS VDD VDD \_0173_
+ sky130_fd_sc_hd__and3_1
* cell instance sky130_fd_sc_hd__and3_1_8 r0 *1 0,0
Xsky130_fd_sc_hd__and3_1_8 mm_p[13] mm_b[14] mm_a[15] VSS VDD VDD \_0167_
+ sky130_fd_sc_hd__and3_1
* cell instance sky130_fd_sc_hd__and3_1_9 r0 *1 0,0
Xsky130_fd_sc_hd__and3_1_9 \_0166_ \_0219_ \_0221_ VSS VDD VDD \_0343_
+ sky130_fd_sc_hd__and3_1
* cell instance sky130_fd_sc_hd__buf_4_0 r0 *1 0,0
Xsky130_fd_sc_hd__buf_4_0 clknet_0_clk VSS VDD VDD clknet_4_0_0_clk
+ sky130_fd_sc_hd__buf_4
* cell instance sky130_fd_sc_hd__buf_4_1 r0 *1 0,0
Xsky130_fd_sc_hd__buf_4_1 clknet_0_clk VSS VDD VDD clknet_4_1_0_clk
+ sky130_fd_sc_hd__buf_4
* cell instance sky130_fd_sc_hd__buf_4_2 r0 *1 0,0
Xsky130_fd_sc_hd__buf_4_2 clknet_0_clk VSS VDD VDD clknet_4_4_0_clk
+ sky130_fd_sc_hd__buf_4
* cell instance sky130_fd_sc_hd__buf_4_3 r0 *1 0,0
Xsky130_fd_sc_hd__buf_4_3 clknet_0_clk VSS VDD VDD clknet_4_5_0_clk
+ sky130_fd_sc_hd__buf_4
* cell instance sky130_fd_sc_hd__buf_4_4 r0 *1 0,0
Xsky130_fd_sc_hd__buf_4_4 \_0143_ VSS VDD VDD net6 sky130_fd_sc_hd__buf_4
* cell instance sky130_fd_sc_hd__buf_4_5 r0 *1 0,0
Xsky130_fd_sc_hd__buf_4_5 \_0438_ VSS VDD VDD net5 sky130_fd_sc_hd__buf_4
* cell instance sky130_fd_sc_hd__buf_4_6 r0 *1 0,0
Xsky130_fd_sc_hd__buf_4_6 clknet_0_clk VSS VDD VDD clknet_4_7_0_clk
+ sky130_fd_sc_hd__buf_4
* cell instance sky130_fd_sc_hd__buf_4_7 r0 *1 0,0
Xsky130_fd_sc_hd__buf_4_7 clknet_0_clk VSS VDD VDD clknet_4_6_0_clk
+ sky130_fd_sc_hd__buf_4
* cell instance sky130_fd_sc_hd__buf_4_8 r0 *1 0,0
Xsky130_fd_sc_hd__buf_4_8 clknet_0_clk VSS VDD VDD clknet_4_2_0_clk
+ sky130_fd_sc_hd__buf_4
* cell instance sky130_fd_sc_hd__buf_4_9 r0 *1 0,0
Xsky130_fd_sc_hd__buf_4_9 clknet_0_clk VSS VDD VDD clknet_4_3_0_clk
+ sky130_fd_sc_hd__buf_4
* cell instance sky130_fd_sc_hd__buf_4_10 r0 *1 0,0
Xsky130_fd_sc_hd__buf_4_10 clk VSS VDD VDD clknet_0_clk sky130_fd_sc_hd__buf_4
* cell instance sky130_fd_sc_hd__buf_4_11 r0 *1 0,0
Xsky130_fd_sc_hd__buf_4_11 clknet_0_clk VSS VDD VDD clknet_4_12_0_clk
+ sky130_fd_sc_hd__buf_4
* cell instance sky130_fd_sc_hd__buf_4_12 r0 *1 0,0
Xsky130_fd_sc_hd__buf_4_12 clknet_0_clk VSS VDD VDD clknet_4_8_0_clk
+ sky130_fd_sc_hd__buf_4
* cell instance sky130_fd_sc_hd__buf_4_13 r0 *1 0,0
Xsky130_fd_sc_hd__buf_4_13 clknet_0_clk VSS VDD VDD clknet_4_9_0_clk
+ sky130_fd_sc_hd__buf_4
* cell instance sky130_fd_sc_hd__buf_4_14 r0 *1 0,0
Xsky130_fd_sc_hd__buf_4_14 clknet_0_clk VSS VDD VDD clknet_4_13_0_clk
+ sky130_fd_sc_hd__buf_4
* cell instance sky130_fd_sc_hd__buf_4_15 r0 *1 0,0
Xsky130_fd_sc_hd__buf_4_15 clknet_0_clk VSS VDD VDD clknet_4_10_0_clk
+ sky130_fd_sc_hd__buf_4
* cell instance sky130_fd_sc_hd__buf_4_16 r0 *1 0,0
Xsky130_fd_sc_hd__buf_4_16 clknet_0_clk VSS VDD VDD clknet_4_15_0_clk
+ sky130_fd_sc_hd__buf_4
* cell instance sky130_fd_sc_hd__buf_4_17 r0 *1 0,0
Xsky130_fd_sc_hd__buf_4_17 clknet_0_clk VSS VDD VDD clknet_4_14_0_clk
+ sky130_fd_sc_hd__buf_4
* cell instance sky130_fd_sc_hd__buf_4_18 r0 *1 0,0
Xsky130_fd_sc_hd__buf_4_18 clknet_0_clk VSS VDD VDD clknet_4_11_0_clk
+ sky130_fd_sc_hd__buf_4
* cell instance sky130_fd_sc_hd__buf_4_19 r0 *1 0,0
Xsky130_fd_sc_hd__buf_4_19 \_0290_ VSS VDD VDD net4 sky130_fd_sc_hd__buf_4
* cell instance sky130_fd_sc_hd__bufinv_16_0 r0 *1 0,0
Xsky130_fd_sc_hd__bufinv_16_0 clknet_4_6_0_clk VSS VDD VDD \$1802
+ sky130_fd_sc_hd__bufinv_16
* cell instance sky130_fd_sc_hd__bufinv_16_1 r0 *1 0,0
Xsky130_fd_sc_hd__bufinv_16_1 clknet_4_2_0_clk VSS VDD VDD \$862
+ sky130_fd_sc_hd__bufinv_16
* cell instance sky130_fd_sc_hd__bufinv_16_2 r0 *1 0,0
Xsky130_fd_sc_hd__bufinv_16_2 clknet_4_3_0_clk VSS VDD VDD \$534
+ sky130_fd_sc_hd__bufinv_16
* cell instance sky130_fd_sc_hd__bufinv_16_3 r0 *1 0,0
Xsky130_fd_sc_hd__bufinv_16_3 clknet_4_12_0_clk VSS VDD VDD \$1568
+ sky130_fd_sc_hd__bufinv_16
* cell instance sky130_fd_sc_hd__bufinv_16_4 r0 *1 0,0
Xsky130_fd_sc_hd__bufinv_16_4 clknet_4_8_0_clk VSS VDD VDD \$395
+ sky130_fd_sc_hd__bufinv_16
* cell instance sky130_fd_sc_hd__bufinv_16_5 r0 *1 0,0
Xsky130_fd_sc_hd__bufinv_16_5 clknet_4_14_0_clk VSS VDD VDD \$1884
+ sky130_fd_sc_hd__bufinv_16
* cell instance sky130_fd_sc_hd__clkinv_1_0 r0 *1 0,0
Xsky130_fd_sc_hd__clkinv_1_0 outer[3] VSS VDD VDD \_0129_
+ sky130_fd_sc_hd__clkinv_1
* cell instance sky130_fd_sc_hd__clkinv_1_1 r0 *1 0,0
Xsky130_fd_sc_hd__clkinv_1_1 outer[4] VSS VDD VDD \_0132_
+ sky130_fd_sc_hd__clkinv_1
* cell instance sky130_fd_sc_hd__clkinv_1_2 r0 *1 0,0
Xsky130_fd_sc_hd__clkinv_1_2 \_0134_ VSS VDD VDD \_0135_
+ sky130_fd_sc_hd__clkinv_1
* cell instance sky130_fd_sc_hd__clkinv_1_3 r0 *1 0,0
Xsky130_fd_sc_hd__clkinv_1_3 \_0136_ VSS VDD VDD \_0000_
+ sky130_fd_sc_hd__clkinv_1
* cell instance sky130_fd_sc_hd__clkinv_1_4 r0 *1 0,0
Xsky130_fd_sc_hd__clkinv_1_4 clknet_4_1_0_clk VSS VDD VDD \$843
+ sky130_fd_sc_hd__clkinv_1
* cell instance sky130_fd_sc_hd__clkinv_1_5 r0 *1 0,0
Xsky130_fd_sc_hd__clkinv_1_5 \_0153_ VSS VDD VDD \_0012_
+ sky130_fd_sc_hd__clkinv_1
* cell instance sky130_fd_sc_hd__clkinv_1_6 r0 *1 0,0
Xsky130_fd_sc_hd__clkinv_1_6 \_0152_ VSS VDD VDD \_0011_
+ sky130_fd_sc_hd__clkinv_1
* cell instance sky130_fd_sc_hd__clkinv_1_7 r0 *1 0,0
Xsky130_fd_sc_hd__clkinv_1_7 result[0] VSS VDD VDD \_0130_
+ sky130_fd_sc_hd__clkinv_1
* cell instance sky130_fd_sc_hd__clkinv_1_8 r0 *1 0,0
Xsky130_fd_sc_hd__clkinv_1_8 \_0151_ VSS VDD VDD \_0010_
+ sky130_fd_sc_hd__clkinv_1
* cell instance sky130_fd_sc_hd__clkinv_1_9 r0 *1 0,0
Xsky130_fd_sc_hd__clkinv_1_9 \_0150_ VSS VDD VDD \_0009_
+ sky130_fd_sc_hd__clkinv_1
* cell instance sky130_fd_sc_hd__clkinv_1_10 r0 *1 0,0
Xsky130_fd_sc_hd__clkinv_1_10 \_0149_ VSS VDD VDD \_0008_
+ sky130_fd_sc_hd__clkinv_1
* cell instance sky130_fd_sc_hd__clkinv_1_11 r0 *1 0,0
Xsky130_fd_sc_hd__clkinv_1_11 \_0190_ VSS VDD VDD \_0191_
+ sky130_fd_sc_hd__clkinv_1
* cell instance sky130_fd_sc_hd__clkinv_1_12 r0 *1 0,0
Xsky130_fd_sc_hd__clkinv_1_12 \_0183_ VSS VDD VDD \_0184_
+ sky130_fd_sc_hd__clkinv_1
* cell instance sky130_fd_sc_hd__clkinv_1_13 r0 *1 0,0
Xsky130_fd_sc_hd__clkinv_1_13 \_0240_ VSS VDD VDD \_0241_
+ sky130_fd_sc_hd__clkinv_1
* cell instance sky130_fd_sc_hd__clkinv_1_14 r0 *1 0,0
Xsky130_fd_sc_hd__clkinv_1_14 \_0148_ VSS VDD VDD \_0007_
+ sky130_fd_sc_hd__clkinv_1
* cell instance sky130_fd_sc_hd__clkinv_1_15 r0 *1 0,0
Xsky130_fd_sc_hd__clkinv_1_15 \_0300_ VSS VDD VDD \_0301_
+ sky130_fd_sc_hd__clkinv_1
* cell instance sky130_fd_sc_hd__clkinv_1_16 r0 *1 0,0
Xsky130_fd_sc_hd__clkinv_1_16 \_0180_ VSS VDD VDD \_0181_
+ sky130_fd_sc_hd__clkinv_1
* cell instance sky130_fd_sc_hd__clkinv_1_17 r0 *1 0,0
Xsky130_fd_sc_hd__clkinv_1_17 \_0147_ VSS VDD VDD \_0006_
+ sky130_fd_sc_hd__clkinv_1
* cell instance sky130_fd_sc_hd__clkinv_1_18 r0 *1 0,0
Xsky130_fd_sc_hd__clkinv_1_18 \_0177_ VSS VDD VDD \_0178_
+ sky130_fd_sc_hd__clkinv_1
* cell instance sky130_fd_sc_hd__clkinv_1_19 r0 *1 0,0
Xsky130_fd_sc_hd__clkinv_1_19 \_0551_ VSS VDD VDD \_0128_
+ sky130_fd_sc_hd__clkinv_1
* cell instance sky130_fd_sc_hd__clkinv_1_20 r0 *1 0,0
Xsky130_fd_sc_hd__clkinv_1_20 \_0536_ VSS VDD VDD \_0117_
+ sky130_fd_sc_hd__clkinv_1
* cell instance sky130_fd_sc_hd__clkinv_1_21 r0 *1 0,0
Xsky130_fd_sc_hd__clkinv_1_21 mm_phase VSS VDD VDD \_0131_
+ sky130_fd_sc_hd__clkinv_1
* cell instance sky130_fd_sc_hd__clkinv_1_22 r0 *1 0,0
Xsky130_fd_sc_hd__clkinv_1_22 \_0550_ VSS VDD VDD \_0127_
+ sky130_fd_sc_hd__clkinv_1
* cell instance sky130_fd_sc_hd__clkinv_1_23 r0 *1 0,0
Xsky130_fd_sc_hd__clkinv_1_23 \_0549_ VSS VDD VDD \_0126_
+ sky130_fd_sc_hd__clkinv_1
* cell instance sky130_fd_sc_hd__clkinv_1_24 r0 *1 0,0
Xsky130_fd_sc_hd__clkinv_1_24 \_0548_ VSS VDD VDD \_0125_
+ sky130_fd_sc_hd__clkinv_1
* cell instance sky130_fd_sc_hd__clkinv_1_25 r0 *1 0,0
Xsky130_fd_sc_hd__clkinv_1_25 \_0546_ VSS VDD VDD \_0123_
+ sky130_fd_sc_hd__clkinv_1
* cell instance sky130_fd_sc_hd__clkinv_1_26 r0 *1 0,0
Xsky130_fd_sc_hd__clkinv_1_26 \_0545_ VSS VDD VDD \_0122_
+ sky130_fd_sc_hd__clkinv_1
* cell instance sky130_fd_sc_hd__clkinv_1_27 r0 *1 0,0
Xsky130_fd_sc_hd__clkinv_1_27 \_0547_ VSS VDD VDD \_0124_
+ sky130_fd_sc_hd__clkinv_1
* cell instance sky130_fd_sc_hd__clkinv_2_0 r0 *1 0,0
Xsky130_fd_sc_hd__clkinv_2_0 clknet_4_9_0_clk VSS VDD VDD \$637
+ sky130_fd_sc_hd__clkinv_2
* cell instance sky130_fd_sc_hd__clkinv_4_0 r0 *1 0,0
Xsky130_fd_sc_hd__clkinv_4_0 clknet_4_4_0_clk VSS VDD VDD \$1657
+ sky130_fd_sc_hd__clkinv_4
* cell instance sky130_fd_sc_hd__clkinv_4_1 r0 *1 0,0
Xsky130_fd_sc_hd__clkinv_4_1 clknet_4_7_0_clk VSS VDD VDD \$1915
+ sky130_fd_sc_hd__clkinv_4
* cell instance sky130_fd_sc_hd__clkinv_4_2 r0 *1 0,0
Xsky130_fd_sc_hd__clkinv_4_2 clknet_4_13_0_clk VSS VDD VDD \$1683
+ sky130_fd_sc_hd__clkinv_4
* cell instance sky130_fd_sc_hd__clkinv_4_3 r0 *1 0,0
Xsky130_fd_sc_hd__clkinv_4_3 clknet_4_15_0_clk VSS VDD VDD \$1998
+ sky130_fd_sc_hd__clkinv_4
* cell instance sky130_fd_sc_hd__conb_1_0 r0 *1 0,0
Xsky130_fd_sc_hd__conb_1_0 VDD \_tie_zero_ VSS VDD VDD sky130_fd_sc_hd__conb_1
* cell instance sky130_fd_sc_hd__dfrtp_1_0 r0 *1 0,0
Xsky130_fd_sc_hd__dfrtp_1_0 clknet_4_0_0_clk \_0120_ outer[4] rst_n VSS VDD VDD
+ sky130_fd_sc_hd__dfrtp_1
* cell instance sky130_fd_sc_hd__dfrtp_1_1 r0 *1 0,0
Xsky130_fd_sc_hd__dfrtp_1_1 clknet_4_0_0_clk \_0115_ outer[2] rst_n VSS VDD VDD
+ sky130_fd_sc_hd__dfrtp_1
* cell instance sky130_fd_sc_hd__dfrtp_1_2 r0 *1 0,0
Xsky130_fd_sc_hd__dfrtp_1_2 clknet_4_0_0_clk \_0114_ outer[3] rst_n VSS VDD VDD
+ sky130_fd_sc_hd__dfrtp_1
* cell instance sky130_fd_sc_hd__dfrtp_1_3 r0 *1 0,0
Xsky130_fd_sc_hd__dfrtp_1_3 clknet_4_1_0_clk \_0118_ outer[1] rst_n VSS VDD VDD
+ sky130_fd_sc_hd__dfrtp_1
* cell instance sky130_fd_sc_hd__dfrtp_1_4 r0 *1 0,0
Xsky130_fd_sc_hd__dfrtp_1_4 clknet_4_4_0_clk \_0014_ j[3] rst_n VSS VDD VDD
+ sky130_fd_sc_hd__dfrtp_1
* cell instance sky130_fd_sc_hd__dfrtp_1_5 r0 *1 0,0
Xsky130_fd_sc_hd__dfrtp_1_5 clknet_4_1_0_clk \_0119_ outer[0] rst_n VSS VDD VDD
+ sky130_fd_sc_hd__dfrtp_1
* cell instance sky130_fd_sc_hd__dfrtp_1_6 r0 *1 0,0
Xsky130_fd_sc_hd__dfrtp_1_6 clknet_4_4_0_clk \_0015_ j[2] rst_n VSS VDD VDD
+ sky130_fd_sc_hd__dfrtp_1
* cell instance sky130_fd_sc_hd__dfrtp_1_7 r0 *1 0,0
Xsky130_fd_sc_hd__dfrtp_1_7 clknet_4_1_0_clk \_0116_ j[4] rst_n VSS VDD VDD
+ sky130_fd_sc_hd__dfrtp_1
* cell instance sky130_fd_sc_hd__dfrtp_1_8 r0 *1 0,0
Xsky130_fd_sc_hd__dfrtp_1_8 clknet_4_5_0_clk \_0017_ j[0] rst_n VSS VDD VDD
+ sky130_fd_sc_hd__dfrtp_1
* cell instance sky130_fd_sc_hd__dfrtp_1_9 r0 *1 0,0
Xsky130_fd_sc_hd__dfrtp_1_9 clknet_4_1_0_clk \_0005_ state[3] rst_n VSS VDD VDD
+ sky130_fd_sc_hd__dfrtp_1
* cell instance sky130_fd_sc_hd__dfrtp_1_10 r0 *1 0,0
Xsky130_fd_sc_hd__dfrtp_1_10 clknet_4_0_0_clk \_0048_ exp_r[14] rst_n VSS VDD
+ VDD sky130_fd_sc_hd__dfrtp_1
* cell instance sky130_fd_sc_hd__dfrtp_1_11 r0 *1 0,0
Xsky130_fd_sc_hd__dfrtp_1_11 clknet_4_0_0_clk \_0113_ exp_r[0] rst_n VSS VDD
+ VDD sky130_fd_sc_hd__dfrtp_1
* cell instance sky130_fd_sc_hd__dfrtp_1_12 r0 *1 0,0
Xsky130_fd_sc_hd__dfrtp_1_12 clknet_4_0_0_clk \_0121_ exp_r[15] rst_n VSS VDD
+ VDD sky130_fd_sc_hd__dfrtp_1
* cell instance sky130_fd_sc_hd__dfrtp_1_13 r0 *1 0,0
Xsky130_fd_sc_hd__dfrtp_1_13 clknet_4_1_0_clk \_0001_ state[5] rst_n VSS VDD
+ VDD sky130_fd_sc_hd__dfrtp_1
* cell instance sky130_fd_sc_hd__dfrtp_1_14 r0 *1 0,0
Xsky130_fd_sc_hd__dfrtp_1_14 clknet_4_0_0_clk \_0000_ state[4] rst_n VSS VDD
+ VDD sky130_fd_sc_hd__dfrtp_1
* cell instance sky130_fd_sc_hd__dfrtp_1_15 r0 *1 0,0
Xsky130_fd_sc_hd__dfrtp_1_15 clknet_4_4_0_clk \_0004_ state[2] rst_n VSS VDD
+ VDD sky130_fd_sc_hd__dfrtp_1
* cell instance sky130_fd_sc_hd__dfrtp_1_16 r0 *1 0,0
Xsky130_fd_sc_hd__dfrtp_1_16 clknet_4_1_0_clk \_0013_ mm_a[0] rst_n VSS VDD VDD
+ sky130_fd_sc_hd__dfrtp_1
* cell instance sky130_fd_sc_hd__dfrtp_1_17 r0 *1 0,0
Xsky130_fd_sc_hd__dfrtp_1_17 clknet_4_4_0_clk \_0016_ j[1] rst_n VSS VDD VDD
+ sky130_fd_sc_hd__dfrtp_1
* cell instance sky130_fd_sc_hd__dfrtp_1_18 r0 *1 0,0
Xsky130_fd_sc_hd__dfrtp_1_18 clknet_4_5_0_clk \_0080_ mod_r[1] rst_n VSS VDD
+ VDD sky130_fd_sc_hd__dfrtp_1
* cell instance sky130_fd_sc_hd__dfrtp_1_19 r0 *1 0,0
Xsky130_fd_sc_hd__dfrtp_1_19 clknet_4_1_0_clk \_0105_ mm_phase rst_n VSS VDD
+ VDD sky130_fd_sc_hd__dfrtp_1
* cell instance sky130_fd_sc_hd__dfrtp_1_20 r0 *1 0,0
Xsky130_fd_sc_hd__dfrtp_1_20 clknet_4_0_0_clk \_0003_ state[1] rst_n VSS VDD
+ VDD sky130_fd_sc_hd__dfrtp_1
* cell instance sky130_fd_sc_hd__dfrtp_1_21 r0 *1 0,0
Xsky130_fd_sc_hd__dfrtp_1_21 clknet_4_5_0_clk \_0046_ result[1] rst_n VSS VDD
+ VDD sky130_fd_sc_hd__dfrtp_1
* cell instance sky130_fd_sc_hd__dfrtp_1_22 r0 *1 0,0
Xsky130_fd_sc_hd__dfrtp_1_22 clknet_4_5_0_clk \_0031_ mm_p[1] rst_n VSS VDD VDD
+ sky130_fd_sc_hd__dfrtp_1
* cell instance sky130_fd_sc_hd__dfrtp_1_23 r0 *1 0,0
Xsky130_fd_sc_hd__dfrtp_1_23 clknet_4_0_0_clk \_0112_ exp_r[1] rst_n VSS VDD
+ VDD sky130_fd_sc_hd__dfrtp_1
* cell instance sky130_fd_sc_hd__dfrtp_1_24 r0 *1 0,0
Xsky130_fd_sc_hd__dfrtp_1_24 clknet_4_4_0_clk \_0012_ mm_a[1] rst_n VSS VDD VDD
+ sky130_fd_sc_hd__dfrtp_1
* cell instance sky130_fd_sc_hd__dfrtp_1_25 r0 *1 0,0
Xsky130_fd_sc_hd__dfrtp_1_25 clknet_4_0_0_clk state[4] done rst_n VSS VDD VDD
+ sky130_fd_sc_hd__dfrtp_1
* cell instance sky130_fd_sc_hd__dfrtp_1_26 r0 *1 0,0
Xsky130_fd_sc_hd__dfrtp_1_26 clknet_4_1_0_clk \_0047_ result[0] rst_n VSS VDD
+ VDD sky130_fd_sc_hd__dfrtp_1
* cell instance sky130_fd_sc_hd__dfrtp_1_27 r0 *1 0,0
Xsky130_fd_sc_hd__dfrtp_1_27 clknet_4_5_0_clk \_0030_ mm_p[2] rst_n VSS VDD VDD
+ sky130_fd_sc_hd__dfrtp_1
* cell instance sky130_fd_sc_hd__dfrtp_1_28 r0 *1 0,0
Xsky130_fd_sc_hd__dfrtp_1_28 clknet_4_1_0_clk \_0011_ mm_a[2] rst_n VSS VDD VDD
+ sky130_fd_sc_hd__dfrtp_1
* cell instance sky130_fd_sc_hd__dfrtp_1_29 r0 *1 0,0
Xsky130_fd_sc_hd__dfrtp_1_29 clknet_4_4_0_clk \_0045_ result[2] rst_n VSS VDD
+ VDD sky130_fd_sc_hd__dfrtp_1
* cell instance sky130_fd_sc_hd__dfrtp_1_30 r0 *1 0,0
Xsky130_fd_sc_hd__dfrtp_1_30 clknet_4_3_0_clk \_0049_ exp_r[13] rst_n VSS VDD
+ VDD sky130_fd_sc_hd__dfrtp_1
* cell instance sky130_fd_sc_hd__dfrtp_1_31 r0 *1 0,0
Xsky130_fd_sc_hd__dfrtp_1_31 clknet_4_1_0_clk \_0065_ base_r[1] rst_n VSS VDD
+ VDD sky130_fd_sc_hd__dfrtp_1
* cell instance sky130_fd_sc_hd__dfrtp_1_32 r0 *1 0,0
Xsky130_fd_sc_hd__dfrtp_1_32 clknet_4_2_0_clk \_0081_ mod_r[0] rst_n VSS VDD
+ VDD sky130_fd_sc_hd__dfrtp_1
* cell instance sky130_fd_sc_hd__dfrtp_1_33 r0 *1 0,0
Xsky130_fd_sc_hd__dfrtp_1_33 clknet_4_2_0_clk \_0111_ exp_r[2] rst_n VSS VDD
+ VDD sky130_fd_sc_hd__dfrtp_1
* cell instance sky130_fd_sc_hd__dfrtp_1_34 r0 *1 0,0
Xsky130_fd_sc_hd__dfrtp_1_34 clknet_4_6_0_clk \_0097_ mm_b[1] rst_n VSS VDD VDD
+ sky130_fd_sc_hd__dfrtp_1
* cell instance sky130_fd_sc_hd__dfrtp_1_35 r0 *1 0,0
Xsky130_fd_sc_hd__dfrtp_1_35 clknet_4_7_0_clk \_0077_ mod_r[4] rst_n VSS VDD
+ VDD sky130_fd_sc_hd__dfrtp_1
* cell instance sky130_fd_sc_hd__dfrtp_1_36 r0 *1 0,0
Xsky130_fd_sc_hd__dfrtp_1_36 clknet_4_2_0_clk \_0050_ exp_r[12] rst_n VSS VDD
+ VDD sky130_fd_sc_hd__dfrtp_1
* cell instance sky130_fd_sc_hd__dfrtp_1_37 r0 *1 0,0
Xsky130_fd_sc_hd__dfrtp_1_37 clknet_4_3_0_clk \_0064_ base_r[2] rst_n VSS VDD
+ VDD sky130_fd_sc_hd__dfrtp_1
* cell instance sky130_fd_sc_hd__dfrtp_1_38 r0 *1 0,0
Xsky130_fd_sc_hd__dfrtp_1_38 clknet_4_6_0_clk \_0098_ mm_b[0] rst_n VSS VDD VDD
+ sky130_fd_sc_hd__dfrtp_1
* cell instance sky130_fd_sc_hd__dfrtp_1_39 r0 *1 0,0
Xsky130_fd_sc_hd__dfrtp_1_39 clknet_4_6_0_clk \_0032_ mm_p[0] rst_n VSS VDD VDD
+ sky130_fd_sc_hd__dfrtp_1
* cell instance sky130_fd_sc_hd__dfrtp_1_40 r0 *1 0,0
Xsky130_fd_sc_hd__dfrtp_1_40 clknet_4_7_0_clk \_0075_ mod_r[6] rst_n VSS VDD
+ VDD sky130_fd_sc_hd__dfrtp_1
* cell instance sky130_fd_sc_hd__dfrtp_1_41 r0 *1 0,0
Xsky130_fd_sc_hd__dfrtp_1_41 clknet_4_3_0_clk \_0069_ mod_r[12] rst_n VSS VDD
+ VDD sky130_fd_sc_hd__dfrtp_1
* cell instance sky130_fd_sc_hd__dfrtp_1_42 r0 *1 0,0
Xsky130_fd_sc_hd__dfrtp_1_42 clknet_4_7_0_clk \_0029_ mm_p[3] rst_n VSS VDD VDD
+ sky130_fd_sc_hd__dfrtp_1
* cell instance sky130_fd_sc_hd__dfrtp_1_43 r0 *1 0,0
Xsky130_fd_sc_hd__dfrtp_1_43 clknet_4_2_0_clk \_0109_ exp_r[3] rst_n VSS VDD
+ VDD sky130_fd_sc_hd__dfrtp_1
* cell instance sky130_fd_sc_hd__dfrtp_1_44 r0 *1 0,0
Xsky130_fd_sc_hd__dfrtp_1_44 clknet_4_3_0_clk \_0096_ mm_b[2] rst_n VSS VDD VDD
+ sky130_fd_sc_hd__dfrtp_1
* cell instance sky130_fd_sc_hd__dfrtp_1_45 r0 *1 0,0
Xsky130_fd_sc_hd__dfrtp_1_45 clknet_4_6_0_clk \_0042_ result[5] rst_n VSS VDD
+ VDD sky130_fd_sc_hd__dfrtp_1
* cell instance sky130_fd_sc_hd__dfrtp_1_46 r0 *1 0,0
Xsky130_fd_sc_hd__dfrtp_1_46 clknet_4_6_0_clk \_0094_ mm_b[4] rst_n VSS VDD VDD
+ sky130_fd_sc_hd__dfrtp_1
* cell instance sky130_fd_sc_hd__dfrtp_1_47 r0 *1 0,0
Xsky130_fd_sc_hd__dfrtp_1_47 clknet_4_7_0_clk \_0027_ mm_p[5] rst_n VSS VDD VDD
+ sky130_fd_sc_hd__dfrtp_1
* cell instance sky130_fd_sc_hd__dfrtp_1_48 r0 *1 0,0
Xsky130_fd_sc_hd__dfrtp_1_48 clknet_4_3_0_clk \_0078_ mod_r[3] rst_n VSS VDD
+ VDD sky130_fd_sc_hd__dfrtp_1
* cell instance sky130_fd_sc_hd__dfrtp_1_49 r0 *1 0,0
Xsky130_fd_sc_hd__dfrtp_1_49 clknet_4_2_0_clk \_0051_ exp_r[11] rst_n VSS VDD
+ VDD sky130_fd_sc_hd__dfrtp_1
* cell instance sky130_fd_sc_hd__dfrtp_1_50 r0 *1 0,0
Xsky130_fd_sc_hd__dfrtp_1_50 clknet_4_3_0_clk \_0062_ base_r[4] rst_n VSS VDD
+ VDD sky130_fd_sc_hd__dfrtp_1
* cell instance sky130_fd_sc_hd__dfrtp_1_51 r0 *1 0,0
Xsky130_fd_sc_hd__dfrtp_1_51 clknet_4_6_0_clk \_0095_ mm_b[3] rst_n VSS VDD VDD
+ sky130_fd_sc_hd__dfrtp_1
* cell instance sky130_fd_sc_hd__dfrtp_1_52 r0 *1 0,0
Xsky130_fd_sc_hd__dfrtp_1_52 clknet_4_2_0_clk \_0107_ exp_r[4] rst_n VSS VDD
+ VDD sky130_fd_sc_hd__dfrtp_1
* cell instance sky130_fd_sc_hd__dfrtp_1_53 r0 *1 0,0
Xsky130_fd_sc_hd__dfrtp_1_53 clknet_4_6_0_clk \_0044_ result[3] rst_n VSS VDD
+ VDD sky130_fd_sc_hd__dfrtp_1
* cell instance sky130_fd_sc_hd__dfrtp_1_54 r0 *1 0,0
Xsky130_fd_sc_hd__dfrtp_1_54 clknet_4_3_0_clk \_0010_ mm_a[3] rst_n VSS VDD VDD
+ sky130_fd_sc_hd__dfrtp_1
* cell instance sky130_fd_sc_hd__dfrtp_1_55 r0 *1 0,0
Xsky130_fd_sc_hd__dfrtp_1_55 clknet_4_6_0_clk \_0063_ base_r[3] rst_n VSS VDD
+ VDD sky130_fd_sc_hd__dfrtp_1
* cell instance sky130_fd_sc_hd__dfrtp_1_56 r0 *1 0,0
Xsky130_fd_sc_hd__dfrtp_1_56 clknet_4_3_0_clk \_0009_ mm_a[4] rst_n VSS VDD VDD
+ sky130_fd_sc_hd__dfrtp_1
* cell instance sky130_fd_sc_hd__dfrtp_1_57 r0 *1 0,0
Xsky130_fd_sc_hd__dfrtp_1_57 clknet_4_7_0_clk \_0028_ mm_p[4] rst_n VSS VDD VDD
+ sky130_fd_sc_hd__dfrtp_1
* cell instance sky130_fd_sc_hd__dfrtp_1_58 r0 *1 0,0
Xsky130_fd_sc_hd__dfrtp_1_58 clknet_4_7_0_clk \_0076_ mod_r[5] rst_n VSS VDD
+ VDD sky130_fd_sc_hd__dfrtp_1
* cell instance sky130_fd_sc_hd__dfrtp_1_59 r0 *1 0,0
Xsky130_fd_sc_hd__dfrtp_1_59 clknet_4_2_0_clk \_0061_ base_r[5] rst_n VSS VDD
+ VDD sky130_fd_sc_hd__dfrtp_1
* cell instance sky130_fd_sc_hd__dfrtp_1_60 r0 *1 0,0
Xsky130_fd_sc_hd__dfrtp_1_60 clknet_4_2_0_clk \_0099_ exp_r[10] rst_n VSS VDD
+ VDD sky130_fd_sc_hd__dfrtp_1
* cell instance sky130_fd_sc_hd__dfrtp_1_61 r0 *1 0,0
Xsky130_fd_sc_hd__dfrtp_1_61 clknet_4_8_0_clk \_0093_ mm_b[5] rst_n VSS VDD VDD
+ sky130_fd_sc_hd__dfrtp_1
* cell instance sky130_fd_sc_hd__dfrtp_1_62 r0 *1 0,0
Xsky130_fd_sc_hd__dfrtp_1_62 clknet_4_12_0_clk \_0092_ mm_b[6] rst_n VSS VDD
+ VDD sky130_fd_sc_hd__dfrtp_1
* cell instance sky130_fd_sc_hd__dfrtp_1_63 r0 *1 0,0
Xsky130_fd_sc_hd__dfrtp_1_63 clknet_4_12_0_clk \_0043_ result[4] rst_n VSS VDD
+ VDD sky130_fd_sc_hd__dfrtp_1
* cell instance sky130_fd_sc_hd__dfrtp_1_64 r0 *1 0,0
Xsky130_fd_sc_hd__dfrtp_1_64 clknet_4_12_0_clk \_0059_ base_r[7] rst_n VSS VDD
+ VDD sky130_fd_sc_hd__dfrtp_1
* cell instance sky130_fd_sc_hd__dfrtp_1_65 r0 *1 0,0
Xsky130_fd_sc_hd__dfrtp_1_65 clknet_4_9_0_clk \_0056_ base_r[10] rst_n VSS VDD
+ VDD sky130_fd_sc_hd__dfrtp_1
* cell instance sky130_fd_sc_hd__dfrtp_1_66 r0 *1 0,0
Xsky130_fd_sc_hd__dfrtp_1_66 clknet_4_13_0_clk \_0026_ mm_p[6] rst_n VSS VDD
+ VDD sky130_fd_sc_hd__dfrtp_1
* cell instance sky130_fd_sc_hd__dfrtp_1_67 r0 *1 0,0
Xsky130_fd_sc_hd__dfrtp_1_67 clknet_4_8_0_clk \_0106_ exp_r[5] rst_n VSS VDD
+ VDD sky130_fd_sc_hd__dfrtp_1
* cell instance sky130_fd_sc_hd__dfrtp_1_68 r0 *1 0,0
Xsky130_fd_sc_hd__dfrtp_1_68 clknet_4_9_0_clk \_0008_ mm_a[5] rst_n VSS VDD VDD
+ sky130_fd_sc_hd__dfrtp_1
* cell instance sky130_fd_sc_hd__dfrtp_1_69 r0 *1 0,0
Xsky130_fd_sc_hd__dfrtp_1_69 clknet_4_13_0_clk \_0025_ mm_p[7] rst_n VSS VDD
+ VDD sky130_fd_sc_hd__dfrtp_1
* cell instance sky130_fd_sc_hd__dfrtp_1_70 r0 *1 0,0
Xsky130_fd_sc_hd__dfrtp_1_70 clknet_4_8_0_clk \_0101_ exp_r[9] rst_n VSS VDD
+ VDD sky130_fd_sc_hd__dfrtp_1
* cell instance sky130_fd_sc_hd__dfrtp_1_71 r0 *1 0,0
Xsky130_fd_sc_hd__dfrtp_1_71 clknet_4_9_0_clk \_0057_ base_r[9] rst_n VSS VDD
+ VDD sky130_fd_sc_hd__dfrtp_1
* cell instance sky130_fd_sc_hd__dfrtp_1_72 r0 *1 0,0
Xsky130_fd_sc_hd__dfrtp_1_72 clknet_4_9_0_clk \_0072_ mod_r[9] rst_n VSS VDD
+ VDD sky130_fd_sc_hd__dfrtp_1
* cell instance sky130_fd_sc_hd__dfrtp_1_73 r0 *1 0,0
Xsky130_fd_sc_hd__dfrtp_1_73 clknet_4_12_0_clk \_0091_ mm_b[7] rst_n VSS VDD
+ VDD sky130_fd_sc_hd__dfrtp_1
* cell instance sky130_fd_sc_hd__dfrtp_1_74 r0 *1 0,0
Xsky130_fd_sc_hd__dfrtp_1_74 clknet_4_13_0_clk \_0041_ result[6] rst_n VSS VDD
+ VDD sky130_fd_sc_hd__dfrtp_1
* cell instance sky130_fd_sc_hd__dfrtp_1_75 r0 *1 0,0
Xsky130_fd_sc_hd__dfrtp_1_75 clknet_4_9_0_clk \_0074_ mod_r[7] rst_n VSS VDD
+ VDD sky130_fd_sc_hd__dfrtp_1
* cell instance sky130_fd_sc_hd__dfrtp_1_76 r0 *1 0,0
Xsky130_fd_sc_hd__dfrtp_1_76 clknet_4_8_0_clk \_0104_ exp_r[6] rst_n VSS VDD
+ VDD sky130_fd_sc_hd__dfrtp_1
* cell instance sky130_fd_sc_hd__dfrtp_1_77 r0 *1 0,0
Xsky130_fd_sc_hd__dfrtp_1_77 clknet_4_9_0_clk \_0073_ mod_r[8] rst_n VSS VDD
+ VDD sky130_fd_sc_hd__dfrtp_1
* cell instance sky130_fd_sc_hd__dfrtp_1_78 r0 *1 0,0
Xsky130_fd_sc_hd__dfrtp_1_78 clknet_4_9_0_clk \_0060_ base_r[6] rst_n VSS VDD
+ VDD sky130_fd_sc_hd__dfrtp_1
* cell instance sky130_fd_sc_hd__dfrtp_1_79 r0 *1 0,0
Xsky130_fd_sc_hd__dfrtp_1_79 clknet_4_12_0_clk \_0088_ mm_b[9] rst_n VSS VDD
+ VDD sky130_fd_sc_hd__dfrtp_1
* cell instance sky130_fd_sc_hd__dfrtp_1_80 r0 *1 0,0
Xsky130_fd_sc_hd__dfrtp_1_80 clknet_4_12_0_clk \_0079_ mod_r[2] rst_n VSS VDD
+ VDD sky130_fd_sc_hd__dfrtp_1
* cell instance sky130_fd_sc_hd__dfrtp_1_81 r0 *1 0,0
Xsky130_fd_sc_hd__dfrtp_1_81 clknet_4_13_0_clk \_0024_ mm_p[8] rst_n VSS VDD
+ VDD sky130_fd_sc_hd__dfrtp_1
* cell instance sky130_fd_sc_hd__dfrtp_1_82 r0 *1 0,0
Xsky130_fd_sc_hd__dfrtp_1_82 clknet_4_13_0_clk \_0040_ result[7] rst_n VSS VDD
+ VDD sky130_fd_sc_hd__dfrtp_1
* cell instance sky130_fd_sc_hd__dfrtp_1_83 r0 *1 0,0
Xsky130_fd_sc_hd__dfrtp_1_83 clknet_4_8_0_clk \_0058_ base_r[8] rst_n VSS VDD
+ VDD sky130_fd_sc_hd__dfrtp_1
* cell instance sky130_fd_sc_hd__dfrtp_1_84 r0 *1 0,0
Xsky130_fd_sc_hd__dfrtp_1_84 clknet_4_8_0_clk \_0102_ exp_r[8] rst_n VSS VDD
+ VDD sky130_fd_sc_hd__dfrtp_1
* cell instance sky130_fd_sc_hd__dfrtp_1_85 r0 *1 0,0
Xsky130_fd_sc_hd__dfrtp_1_85 clknet_4_8_0_clk \_0103_ exp_r[7] rst_n VSS VDD
+ VDD sky130_fd_sc_hd__dfrtp_1
* cell instance sky130_fd_sc_hd__dfrtp_1_86 r0 *1 0,0
Xsky130_fd_sc_hd__dfrtp_1_86 clknet_4_9_0_clk \_0007_ mm_a[6] rst_n VSS VDD VDD
+ sky130_fd_sc_hd__dfrtp_1
* cell instance sky130_fd_sc_hd__dfrtp_1_87 r0 *1 0,0
Xsky130_fd_sc_hd__dfrtp_1_87 clknet_4_13_0_clk \_0023_ mm_p[9] rst_n VSS VDD
+ VDD sky130_fd_sc_hd__dfrtp_1
* cell instance sky130_fd_sc_hd__dfrtp_1_88 r0 *1 0,0
Xsky130_fd_sc_hd__dfrtp_1_88 clknet_4_9_0_clk \_0066_ base_r[0] rst_n VSS VDD
+ VDD sky130_fd_sc_hd__dfrtp_1
* cell instance sky130_fd_sc_hd__dfrtp_1_89 r0 *1 0,0
Xsky130_fd_sc_hd__dfrtp_1_89 clknet_4_12_0_clk \_0086_ mm_b[10] rst_n VSS VDD
+ VDD sky130_fd_sc_hd__dfrtp_1
* cell instance sky130_fd_sc_hd__dfrtp_1_90 r0 *1 0,0
Xsky130_fd_sc_hd__dfrtp_1_90 clknet_4_12_0_clk \_0090_ mm_b[8] rst_n VSS VDD
+ VDD sky130_fd_sc_hd__dfrtp_1
* cell instance sky130_fd_sc_hd__dfrtp_1_91 r0 *1 0,0
Xsky130_fd_sc_hd__dfrtp_1_91 clknet_4_10_0_clk \_0054_ base_r[12] rst_n VSS VDD
+ VDD sky130_fd_sc_hd__dfrtp_1
* cell instance sky130_fd_sc_hd__dfrtp_1_92 r0 *1 0,0
Xsky130_fd_sc_hd__dfrtp_1_92 clknet_4_10_0_clk \_0055_ base_r[11] rst_n VSS VDD
+ VDD sky130_fd_sc_hd__dfrtp_1
* cell instance sky130_fd_sc_hd__dfrtp_1_93 r0 *1 0,0
Xsky130_fd_sc_hd__dfrtp_1_93 clknet_4_8_0_clk \_0006_ mm_a[7] rst_n VSS VDD VDD
+ sky130_fd_sc_hd__dfrtp_1
* cell instance sky130_fd_sc_hd__dfrtp_1_94 r0 *1 0,0
Xsky130_fd_sc_hd__dfrtp_1_94 clknet_4_14_0_clk \_0039_ result[8] rst_n VSS VDD
+ VDD sky130_fd_sc_hd__dfrtp_1
* cell instance sky130_fd_sc_hd__dfrtp_1_95 r0 *1 0,0
Xsky130_fd_sc_hd__dfrtp_1_95 clknet_4_15_0_clk \_0022_ mm_p[10] rst_n VSS VDD
+ VDD sky130_fd_sc_hd__dfrtp_1
* cell instance sky130_fd_sc_hd__dfrtp_1_96 r0 *1 0,0
Xsky130_fd_sc_hd__dfrtp_1_96 clknet_4_10_0_clk \_0071_ mod_r[10] rst_n VSS VDD
+ VDD sky130_fd_sc_hd__dfrtp_1
* cell instance sky130_fd_sc_hd__dfrtp_1_97 r0 *1 0,0
Xsky130_fd_sc_hd__dfrtp_1_97 clknet_4_14_0_clk \_0038_ result[9] rst_n VSS VDD
+ VDD sky130_fd_sc_hd__dfrtp_1
* cell instance sky130_fd_sc_hd__dfrtp_1_98 r0 *1 0,0
Xsky130_fd_sc_hd__dfrtp_1_98 clknet_4_10_0_clk \_0053_ base_r[13] rst_n VSS VDD
+ VDD sky130_fd_sc_hd__dfrtp_1
* cell instance sky130_fd_sc_hd__dfrtp_1_99 r0 *1 0,0
Xsky130_fd_sc_hd__dfrtp_1_99 clknet_4_11_0_clk \_0085_ mm_b[11] rst_n VSS VDD
+ VDD sky130_fd_sc_hd__dfrtp_1
* cell instance sky130_fd_sc_hd__dfrtp_1_100 r0 *1 0,0
Xsky130_fd_sc_hd__dfrtp_1_100 clknet_4_15_0_clk \_0117_ mm_a[15] rst_n VSS VDD
+ VDD sky130_fd_sc_hd__dfrtp_1
* cell instance sky130_fd_sc_hd__dfrtp_1_101 r0 *1 0,0
Xsky130_fd_sc_hd__dfrtp_1_101 clknet_4_14_0_clk \_0084_ mm_b[12] rst_n VSS VDD
+ VDD sky130_fd_sc_hd__dfrtp_1
* cell instance sky130_fd_sc_hd__dfrtp_1_102 r0 *1 0,0
Xsky130_fd_sc_hd__dfrtp_1_102 clknet_4_10_0_clk \_0128_ mm_a[8] rst_n VSS VDD
+ VDD sky130_fd_sc_hd__dfrtp_1
* cell instance sky130_fd_sc_hd__dfrtp_1_103 r0 *1 0,0
Xsky130_fd_sc_hd__dfrtp_1_103 clknet_4_10_0_clk \_0052_ base_r[14] rst_n VSS
+ VDD VDD sky130_fd_sc_hd__dfrtp_1
* cell instance sky130_fd_sc_hd__dfrtp_1_104 r0 *1 0,0
Xsky130_fd_sc_hd__dfrtp_1_104 clknet_4_10_0_clk \_0070_ mod_r[11] rst_n VSS VDD
+ VDD sky130_fd_sc_hd__dfrtp_1
* cell instance sky130_fd_sc_hd__dfrtp_1_105 r0 *1 0,0
Xsky130_fd_sc_hd__dfrtp_1_105 clknet_4_14_0_clk \_0037_ result[10] rst_n VSS
+ VDD VDD sky130_fd_sc_hd__dfrtp_1
* cell instance sky130_fd_sc_hd__dfrtp_1_106 r0 *1 0,0
Xsky130_fd_sc_hd__dfrtp_1_106 clknet_4_15_0_clk \_0021_ mm_p[11] rst_n VSS VDD
+ VDD sky130_fd_sc_hd__dfrtp_1
* cell instance sky130_fd_sc_hd__dfrtp_1_107 r0 *1 0,0
Xsky130_fd_sc_hd__dfrtp_1_107 clknet_4_11_0_clk \_0083_ mm_b[13] rst_n VSS VDD
+ VDD sky130_fd_sc_hd__dfrtp_1
* cell instance sky130_fd_sc_hd__dfrtp_1_108 r0 *1 0,0
Xsky130_fd_sc_hd__dfrtp_1_108 clknet_4_10_0_clk \_0100_ base_r[15] rst_n VSS
+ VDD VDD sky130_fd_sc_hd__dfrtp_1
* cell instance sky130_fd_sc_hd__dfrtp_1_109 r0 *1 0,0
Xsky130_fd_sc_hd__dfrtp_1_109 clknet_4_14_0_clk \_0082_ mm_b[14] rst_n VSS VDD
+ VDD sky130_fd_sc_hd__dfrtp_1
* cell instance sky130_fd_sc_hd__dfrtp_1_110 r0 *1 0,0
Xsky130_fd_sc_hd__dfrtp_1_110 clknet_4_11_0_clk \_0127_ mm_a[9] rst_n VSS VDD
+ VDD sky130_fd_sc_hd__dfrtp_1
* cell instance sky130_fd_sc_hd__dfrtp_1_111 r0 *1 0,0
Xsky130_fd_sc_hd__dfrtp_1_111 clknet_4_11_0_clk \_0087_ mm_b[15] rst_n VSS VDD
+ VDD sky130_fd_sc_hd__dfrtp_1
* cell instance sky130_fd_sc_hd__dfrtp_1_112 r0 *1 0,0
Xsky130_fd_sc_hd__dfrtp_1_112 clknet_4_15_0_clk \_0020_ mm_p[12] rst_n VSS VDD
+ VDD sky130_fd_sc_hd__dfrtp_1
* cell instance sky130_fd_sc_hd__dfrtp_1_113 r0 *1 0,0
Xsky130_fd_sc_hd__dfrtp_1_113 clknet_4_10_0_clk \_0068_ mod_r[13] rst_n VSS VDD
+ VDD sky130_fd_sc_hd__dfrtp_1
* cell instance sky130_fd_sc_hd__dfrtp_1_114 r0 *1 0,0
Xsky130_fd_sc_hd__dfrtp_1_114 clknet_4_10_0_clk \_0067_ mod_r[14] rst_n VSS VDD
+ VDD sky130_fd_sc_hd__dfrtp_1
* cell instance sky130_fd_sc_hd__dfrtp_1_115 r0 *1 0,0
Xsky130_fd_sc_hd__dfrtp_1_115 clknet_4_11_0_clk \_0036_ result[11] rst_n VSS
+ VDD VDD sky130_fd_sc_hd__dfrtp_1
* cell instance sky130_fd_sc_hd__dfrtp_1_116 r0 *1 0,0
Xsky130_fd_sc_hd__dfrtp_1_116 clknet_4_11_0_clk \_0126_ mm_a[10] rst_n VSS VDD
+ VDD sky130_fd_sc_hd__dfrtp_1
* cell instance sky130_fd_sc_hd__dfrtp_1_117 r0 *1 0,0
Xsky130_fd_sc_hd__dfrtp_1_117 clknet_4_11_0_clk \_0033_ result[14] rst_n VSS
+ VDD VDD sky130_fd_sc_hd__dfrtp_1
* cell instance sky130_fd_sc_hd__dfrtp_1_118 r0 *1 0,0
Xsky130_fd_sc_hd__dfrtp_1_118 clknet_4_11_0_clk \_0034_ result[13] rst_n VSS
+ VDD VDD sky130_fd_sc_hd__dfrtp_1
* cell instance sky130_fd_sc_hd__dfrtp_1_119 r0 *1 0,0
Xsky130_fd_sc_hd__dfrtp_1_119 clknet_4_14_0_clk \_0108_ result[15] rst_n VSS
+ VDD VDD sky130_fd_sc_hd__dfrtp_1
* cell instance sky130_fd_sc_hd__dfrtp_1_120 r0 *1 0,0
Xsky130_fd_sc_hd__dfrtp_1_120 clknet_4_10_0_clk \_0089_ mod_r[15] rst_n VSS VDD
+ VDD sky130_fd_sc_hd__dfrtp_1
* cell instance sky130_fd_sc_hd__dfrtp_1_121 r0 *1 0,0
Xsky130_fd_sc_hd__dfrtp_1_121 clknet_4_11_0_clk \_0123_ mm_a[13] rst_n VSS VDD
+ VDD sky130_fd_sc_hd__dfrtp_1
* cell instance sky130_fd_sc_hd__dfrtp_1_122 r0 *1 0,0
Xsky130_fd_sc_hd__dfrtp_1_122 clknet_4_14_0_clk \_0035_ result[12] rst_n VSS
+ VDD VDD sky130_fd_sc_hd__dfrtp_1
* cell instance sky130_fd_sc_hd__dfrtp_1_123 r0 *1 0,0
Xsky130_fd_sc_hd__dfrtp_1_123 clknet_4_10_0_clk \_0125_ mm_a[11] rst_n VSS VDD
+ VDD sky130_fd_sc_hd__dfrtp_1
* cell instance sky130_fd_sc_hd__dfrtp_1_124 r0 *1 0,0
Xsky130_fd_sc_hd__dfrtp_1_124 clknet_4_11_0_clk \_0124_ mm_a[12] rst_n VSS VDD
+ VDD sky130_fd_sc_hd__dfrtp_1
* cell instance sky130_fd_sc_hd__dfrtp_1_125 r0 *1 0,0
Xsky130_fd_sc_hd__dfrtp_1_125 clknet_4_11_0_clk \_0122_ mm_a[14] rst_n VSS VDD
+ VDD sky130_fd_sc_hd__dfrtp_1
* cell instance sky130_fd_sc_hd__dfrtp_1_126 r0 *1 0,0
Xsky130_fd_sc_hd__dfrtp_1_126 clknet_4_14_0_clk \_0110_ mm_p[15] rst_n VSS VDD
+ VDD sky130_fd_sc_hd__dfrtp_1
* cell instance sky130_fd_sc_hd__dfrtp_1_127 r0 *1 0,0
Xsky130_fd_sc_hd__dfrtp_1_127 clknet_4_15_0_clk \_0018_ mm_p[14] rst_n VSS VDD
+ VDD sky130_fd_sc_hd__dfrtp_1
* cell instance sky130_fd_sc_hd__dfrtp_1_128 r0 *1 0,0
Xsky130_fd_sc_hd__dfrtp_1_128 clknet_4_15_0_clk \_0019_ mm_p[13] rst_n VSS VDD
+ VDD sky130_fd_sc_hd__dfrtp_1
* cell instance sky130_fd_sc_hd__dfstp_2_0 r0 *1 0,0
Xsky130_fd_sc_hd__dfstp_2_0 clknet_4_0_0_clk \_0002_ state[0] rst_n VSS VDD VDD
+ sky130_fd_sc_hd__dfstp_2
* cell instance sky130_fd_sc_hd__diode_2_0 r0 *1 0,0
Xsky130_fd_sc_hd__diode_2_0 mod_in[1] VSS VDD VDD sky130_fd_sc_hd__diode_2
* cell instance sky130_fd_sc_hd__diode_2_1 r0 *1 0,0
Xsky130_fd_sc_hd__diode_2_1 mod_in[4] VSS VDD VDD sky130_fd_sc_hd__diode_2
* cell instance sky130_fd_sc_hd__diode_2_2 r0 *1 0,0
Xsky130_fd_sc_hd__diode_2_2 mod_in[6] VSS VDD VDD sky130_fd_sc_hd__diode_2
* cell instance sky130_fd_sc_hd__diode_2_3 r0 *1 0,0
Xsky130_fd_sc_hd__diode_2_3 mod_in[5] VSS VDD VDD sky130_fd_sc_hd__diode_2
* cell instance sky130_fd_sc_hd__fill_1_0 r0 *1 0,0
Xsky130_fd_sc_hd__fill_1_0 VSS VDD VDD sky130_fd_sc_hd__fill_1
* cell instance sky130_fd_sc_hd__fill_1_1 r0 *1 0,0
Xsky130_fd_sc_hd__fill_1_1 VSS VDD VDD sky130_fd_sc_hd__fill_1
* cell instance sky130_fd_sc_hd__fill_1_2 r0 *1 0,0
Xsky130_fd_sc_hd__fill_1_2 VSS VDD VDD sky130_fd_sc_hd__fill_1
* cell instance sky130_fd_sc_hd__fill_1_3 r0 *1 0,0
Xsky130_fd_sc_hd__fill_1_3 VSS VDD VDD sky130_fd_sc_hd__fill_1
* cell instance sky130_fd_sc_hd__fill_1_4 r0 *1 0,0
Xsky130_fd_sc_hd__fill_1_4 VSS VDD VDD sky130_fd_sc_hd__fill_1
* cell instance sky130_fd_sc_hd__fill_1_5 r0 *1 0,0
Xsky130_fd_sc_hd__fill_1_5 VSS VDD VDD sky130_fd_sc_hd__fill_1
* cell instance sky130_fd_sc_hd__fill_1_6 r0 *1 0,0
Xsky130_fd_sc_hd__fill_1_6 VSS VDD VDD sky130_fd_sc_hd__fill_1
* cell instance sky130_fd_sc_hd__fill_1_7 r0 *1 0,0
Xsky130_fd_sc_hd__fill_1_7 VSS VDD VDD sky130_fd_sc_hd__fill_1
* cell instance sky130_fd_sc_hd__fill_1_8 r0 *1 0,0
Xsky130_fd_sc_hd__fill_1_8 VSS VDD VDD sky130_fd_sc_hd__fill_1
* cell instance sky130_fd_sc_hd__fill_1_9 r0 *1 0,0
Xsky130_fd_sc_hd__fill_1_9 VSS VDD VDD sky130_fd_sc_hd__fill_1
* cell instance sky130_fd_sc_hd__fill_1_10 r0 *1 0,0
Xsky130_fd_sc_hd__fill_1_10 VSS VDD VDD sky130_fd_sc_hd__fill_1
* cell instance sky130_fd_sc_hd__fill_1_11 r0 *1 0,0
Xsky130_fd_sc_hd__fill_1_11 VSS VDD VDD sky130_fd_sc_hd__fill_1
* cell instance sky130_fd_sc_hd__fill_1_12 r0 *1 0,0
Xsky130_fd_sc_hd__fill_1_12 VSS VDD VDD sky130_fd_sc_hd__fill_1
* cell instance sky130_fd_sc_hd__fill_1_13 r0 *1 0,0
Xsky130_fd_sc_hd__fill_1_13 VSS VDD VDD sky130_fd_sc_hd__fill_1
* cell instance sky130_fd_sc_hd__fill_1_14 r0 *1 0,0
Xsky130_fd_sc_hd__fill_1_14 VSS VDD VDD sky130_fd_sc_hd__fill_1
* cell instance sky130_fd_sc_hd__fill_1_15 r0 *1 0,0
Xsky130_fd_sc_hd__fill_1_15 VSS VDD VDD sky130_fd_sc_hd__fill_1
* cell instance sky130_fd_sc_hd__fill_1_16 r0 *1 0,0
Xsky130_fd_sc_hd__fill_1_16 VSS VDD VDD sky130_fd_sc_hd__fill_1
* cell instance sky130_fd_sc_hd__fill_1_17 r0 *1 0,0
Xsky130_fd_sc_hd__fill_1_17 VSS VDD VDD sky130_fd_sc_hd__fill_1
* cell instance sky130_fd_sc_hd__fill_1_18 r0 *1 0,0
Xsky130_fd_sc_hd__fill_1_18 VSS VDD VDD sky130_fd_sc_hd__fill_1
* cell instance sky130_fd_sc_hd__fill_1_19 r0 *1 0,0
Xsky130_fd_sc_hd__fill_1_19 VSS VDD VDD sky130_fd_sc_hd__fill_1
* cell instance sky130_fd_sc_hd__fill_1_20 r0 *1 0,0
Xsky130_fd_sc_hd__fill_1_20 VSS VDD VDD sky130_fd_sc_hd__fill_1
* cell instance sky130_fd_sc_hd__fill_1_21 r0 *1 0,0
Xsky130_fd_sc_hd__fill_1_21 VSS VDD VDD sky130_fd_sc_hd__fill_1
* cell instance sky130_fd_sc_hd__fill_1_22 r0 *1 0,0
Xsky130_fd_sc_hd__fill_1_22 VSS VDD VDD sky130_fd_sc_hd__fill_1
* cell instance sky130_fd_sc_hd__fill_1_23 r0 *1 0,0
Xsky130_fd_sc_hd__fill_1_23 VSS VDD VDD sky130_fd_sc_hd__fill_1
* cell instance sky130_fd_sc_hd__fill_1_24 r0 *1 0,0
Xsky130_fd_sc_hd__fill_1_24 VSS VDD VDD sky130_fd_sc_hd__fill_1
* cell instance sky130_fd_sc_hd__fill_1_25 r0 *1 0,0
Xsky130_fd_sc_hd__fill_1_25 VSS VDD VDD sky130_fd_sc_hd__fill_1
* cell instance sky130_fd_sc_hd__fill_1_26 r0 *1 0,0
Xsky130_fd_sc_hd__fill_1_26 VSS VDD VDD sky130_fd_sc_hd__fill_1
* cell instance sky130_fd_sc_hd__fill_1_27 r0 *1 0,0
Xsky130_fd_sc_hd__fill_1_27 VSS VDD VDD sky130_fd_sc_hd__fill_1
* cell instance sky130_fd_sc_hd__fill_1_28 r0 *1 0,0
Xsky130_fd_sc_hd__fill_1_28 VSS VDD VDD sky130_fd_sc_hd__fill_1
* cell instance sky130_fd_sc_hd__fill_1_29 r0 *1 0,0
Xsky130_fd_sc_hd__fill_1_29 VSS VDD VDD sky130_fd_sc_hd__fill_1
* cell instance sky130_fd_sc_hd__fill_1_30 r0 *1 0,0
Xsky130_fd_sc_hd__fill_1_30 VSS VDD VDD sky130_fd_sc_hd__fill_1
* cell instance sky130_fd_sc_hd__fill_1_31 r0 *1 0,0
Xsky130_fd_sc_hd__fill_1_31 VSS VDD VDD sky130_fd_sc_hd__fill_1
* cell instance sky130_fd_sc_hd__fill_1_32 r0 *1 0,0
Xsky130_fd_sc_hd__fill_1_32 VSS VDD VDD sky130_fd_sc_hd__fill_1
* cell instance sky130_fd_sc_hd__fill_1_33 r0 *1 0,0
Xsky130_fd_sc_hd__fill_1_33 VSS VDD VDD sky130_fd_sc_hd__fill_1
* cell instance sky130_fd_sc_hd__fill_1_34 r0 *1 0,0
Xsky130_fd_sc_hd__fill_1_34 VSS VDD VDD sky130_fd_sc_hd__fill_1
* cell instance sky130_fd_sc_hd__fill_1_35 r0 *1 0,0
Xsky130_fd_sc_hd__fill_1_35 VSS VDD VDD sky130_fd_sc_hd__fill_1
* cell instance sky130_fd_sc_hd__fill_1_36 r0 *1 0,0
Xsky130_fd_sc_hd__fill_1_36 VSS VDD VDD sky130_fd_sc_hd__fill_1
* cell instance sky130_fd_sc_hd__fill_1_37 r0 *1 0,0
Xsky130_fd_sc_hd__fill_1_37 VSS VDD VDD sky130_fd_sc_hd__fill_1
* cell instance sky130_fd_sc_hd__fill_1_38 r0 *1 0,0
Xsky130_fd_sc_hd__fill_1_38 VSS VDD VDD sky130_fd_sc_hd__fill_1
* cell instance sky130_fd_sc_hd__fill_1_39 r0 *1 0,0
Xsky130_fd_sc_hd__fill_1_39 VSS VDD VDD sky130_fd_sc_hd__fill_1
* cell instance sky130_fd_sc_hd__fill_1_40 r0 *1 0,0
Xsky130_fd_sc_hd__fill_1_40 VSS VDD VDD sky130_fd_sc_hd__fill_1
* cell instance sky130_fd_sc_hd__fill_1_41 r0 *1 0,0
Xsky130_fd_sc_hd__fill_1_41 VSS VDD VDD sky130_fd_sc_hd__fill_1
* cell instance sky130_fd_sc_hd__fill_1_42 r0 *1 0,0
Xsky130_fd_sc_hd__fill_1_42 VSS VDD VDD sky130_fd_sc_hd__fill_1
* cell instance sky130_fd_sc_hd__fill_1_43 r0 *1 0,0
Xsky130_fd_sc_hd__fill_1_43 VSS VDD VDD sky130_fd_sc_hd__fill_1
* cell instance sky130_fd_sc_hd__fill_1_44 r0 *1 0,0
Xsky130_fd_sc_hd__fill_1_44 VSS VDD VDD sky130_fd_sc_hd__fill_1
* cell instance sky130_fd_sc_hd__fill_1_45 r0 *1 0,0
Xsky130_fd_sc_hd__fill_1_45 VSS VDD VDD sky130_fd_sc_hd__fill_1
* cell instance sky130_fd_sc_hd__fill_1_46 r0 *1 0,0
Xsky130_fd_sc_hd__fill_1_46 VSS VDD VDD sky130_fd_sc_hd__fill_1
* cell instance sky130_fd_sc_hd__fill_1_47 r0 *1 0,0
Xsky130_fd_sc_hd__fill_1_47 VSS VDD VDD sky130_fd_sc_hd__fill_1
* cell instance sky130_fd_sc_hd__fill_1_48 r0 *1 0,0
Xsky130_fd_sc_hd__fill_1_48 VSS VDD VDD sky130_fd_sc_hd__fill_1
* cell instance sky130_fd_sc_hd__fill_1_49 r0 *1 0,0
Xsky130_fd_sc_hd__fill_1_49 VSS VDD VDD sky130_fd_sc_hd__fill_1
* cell instance sky130_fd_sc_hd__fill_1_50 r0 *1 0,0
Xsky130_fd_sc_hd__fill_1_50 VSS VDD VDD sky130_fd_sc_hd__fill_1
* cell instance sky130_fd_sc_hd__fill_1_51 r0 *1 0,0
Xsky130_fd_sc_hd__fill_1_51 VSS VDD VDD sky130_fd_sc_hd__fill_1
* cell instance sky130_fd_sc_hd__fill_1_52 r0 *1 0,0
Xsky130_fd_sc_hd__fill_1_52 VSS VDD VDD sky130_fd_sc_hd__fill_1
* cell instance sky130_fd_sc_hd__fill_1_53 r0 *1 0,0
Xsky130_fd_sc_hd__fill_1_53 VSS VDD VDD sky130_fd_sc_hd__fill_1
* cell instance sky130_fd_sc_hd__fill_1_54 r0 *1 0,0
Xsky130_fd_sc_hd__fill_1_54 VSS VDD VDD sky130_fd_sc_hd__fill_1
* cell instance sky130_fd_sc_hd__fill_1_55 r0 *1 0,0
Xsky130_fd_sc_hd__fill_1_55 VSS VDD VDD sky130_fd_sc_hd__fill_1
* cell instance sky130_fd_sc_hd__fill_1_56 r0 *1 0,0
Xsky130_fd_sc_hd__fill_1_56 VSS VDD VDD sky130_fd_sc_hd__fill_1
* cell instance sky130_fd_sc_hd__fill_1_57 r0 *1 0,0
Xsky130_fd_sc_hd__fill_1_57 VSS VDD VDD sky130_fd_sc_hd__fill_1
* cell instance sky130_fd_sc_hd__fill_1_58 r0 *1 0,0
Xsky130_fd_sc_hd__fill_1_58 VSS VDD VDD sky130_fd_sc_hd__fill_1
* cell instance sky130_fd_sc_hd__fill_1_59 r0 *1 0,0
Xsky130_fd_sc_hd__fill_1_59 VSS VDD VDD sky130_fd_sc_hd__fill_1
* cell instance sky130_fd_sc_hd__fill_1_60 r0 *1 0,0
Xsky130_fd_sc_hd__fill_1_60 VSS VDD VDD sky130_fd_sc_hd__fill_1
* cell instance sky130_fd_sc_hd__fill_1_61 r0 *1 0,0
Xsky130_fd_sc_hd__fill_1_61 VSS VDD VDD sky130_fd_sc_hd__fill_1
* cell instance sky130_fd_sc_hd__fill_1_62 r0 *1 0,0
Xsky130_fd_sc_hd__fill_1_62 VSS VDD VDD sky130_fd_sc_hd__fill_1
* cell instance sky130_fd_sc_hd__fill_1_63 r0 *1 0,0
Xsky130_fd_sc_hd__fill_1_63 VSS VDD VDD sky130_fd_sc_hd__fill_1
* cell instance sky130_fd_sc_hd__fill_1_64 r0 *1 0,0
Xsky130_fd_sc_hd__fill_1_64 VSS VDD VDD sky130_fd_sc_hd__fill_1
* cell instance sky130_fd_sc_hd__fill_1_65 r0 *1 0,0
Xsky130_fd_sc_hd__fill_1_65 VSS VDD VDD sky130_fd_sc_hd__fill_1
* cell instance sky130_fd_sc_hd__fill_1_66 r0 *1 0,0
Xsky130_fd_sc_hd__fill_1_66 VSS VDD VDD sky130_fd_sc_hd__fill_1
* cell instance sky130_fd_sc_hd__fill_1_67 r0 *1 0,0
Xsky130_fd_sc_hd__fill_1_67 VSS VDD VDD sky130_fd_sc_hd__fill_1
* cell instance sky130_fd_sc_hd__fill_1_68 r0 *1 0,0
Xsky130_fd_sc_hd__fill_1_68 VSS VDD VDD sky130_fd_sc_hd__fill_1
* cell instance sky130_fd_sc_hd__fill_1_69 r0 *1 0,0
Xsky130_fd_sc_hd__fill_1_69 VSS VDD VDD sky130_fd_sc_hd__fill_1
* cell instance sky130_fd_sc_hd__fill_1_70 r0 *1 0,0
Xsky130_fd_sc_hd__fill_1_70 VSS VDD VDD sky130_fd_sc_hd__fill_1
* cell instance sky130_fd_sc_hd__fill_1_71 r0 *1 0,0
Xsky130_fd_sc_hd__fill_1_71 VSS VDD VDD sky130_fd_sc_hd__fill_1
* cell instance sky130_fd_sc_hd__fill_1_72 r0 *1 0,0
Xsky130_fd_sc_hd__fill_1_72 VSS VDD VDD sky130_fd_sc_hd__fill_1
* cell instance sky130_fd_sc_hd__fill_1_73 r0 *1 0,0
Xsky130_fd_sc_hd__fill_1_73 VSS VDD VDD sky130_fd_sc_hd__fill_1
* cell instance sky130_fd_sc_hd__fill_1_74 r0 *1 0,0
Xsky130_fd_sc_hd__fill_1_74 VSS VDD VDD sky130_fd_sc_hd__fill_1
* cell instance sky130_fd_sc_hd__fill_1_75 r0 *1 0,0
Xsky130_fd_sc_hd__fill_1_75 VSS VDD VDD sky130_fd_sc_hd__fill_1
* cell instance sky130_fd_sc_hd__fill_1_76 r0 *1 0,0
Xsky130_fd_sc_hd__fill_1_76 VSS VDD VDD sky130_fd_sc_hd__fill_1
* cell instance sky130_fd_sc_hd__fill_1_77 r0 *1 0,0
Xsky130_fd_sc_hd__fill_1_77 VSS VDD VDD sky130_fd_sc_hd__fill_1
* cell instance sky130_fd_sc_hd__fill_1_78 r0 *1 0,0
Xsky130_fd_sc_hd__fill_1_78 VSS VDD VDD sky130_fd_sc_hd__fill_1
* cell instance sky130_fd_sc_hd__fill_1_79 r0 *1 0,0
Xsky130_fd_sc_hd__fill_1_79 VSS VDD VDD sky130_fd_sc_hd__fill_1
* cell instance sky130_fd_sc_hd__fill_1_80 r0 *1 0,0
Xsky130_fd_sc_hd__fill_1_80 VSS VDD VDD sky130_fd_sc_hd__fill_1
* cell instance sky130_fd_sc_hd__fill_1_81 r0 *1 0,0
Xsky130_fd_sc_hd__fill_1_81 VSS VDD VDD sky130_fd_sc_hd__fill_1
* cell instance sky130_fd_sc_hd__fill_1_82 r0 *1 0,0
Xsky130_fd_sc_hd__fill_1_82 VSS VDD VDD sky130_fd_sc_hd__fill_1
* cell instance sky130_fd_sc_hd__fill_1_83 r0 *1 0,0
Xsky130_fd_sc_hd__fill_1_83 VSS VDD VDD sky130_fd_sc_hd__fill_1
* cell instance sky130_fd_sc_hd__fill_1_84 r0 *1 0,0
Xsky130_fd_sc_hd__fill_1_84 VSS VDD VDD sky130_fd_sc_hd__fill_1
* cell instance sky130_fd_sc_hd__fill_1_85 r0 *1 0,0
Xsky130_fd_sc_hd__fill_1_85 VSS VDD VDD sky130_fd_sc_hd__fill_1
* cell instance sky130_fd_sc_hd__fill_1_86 r0 *1 0,0
Xsky130_fd_sc_hd__fill_1_86 VSS VDD VDD sky130_fd_sc_hd__fill_1
* cell instance sky130_fd_sc_hd__fill_1_87 r0 *1 0,0
Xsky130_fd_sc_hd__fill_1_87 VSS VDD VDD sky130_fd_sc_hd__fill_1
* cell instance sky130_fd_sc_hd__fill_1_88 r0 *1 0,0
Xsky130_fd_sc_hd__fill_1_88 VSS VDD VDD sky130_fd_sc_hd__fill_1
* cell instance sky130_fd_sc_hd__fill_1_89 r0 *1 0,0
Xsky130_fd_sc_hd__fill_1_89 VSS VDD VDD sky130_fd_sc_hd__fill_1
* cell instance sky130_fd_sc_hd__fill_1_90 r0 *1 0,0
Xsky130_fd_sc_hd__fill_1_90 VSS VDD VDD sky130_fd_sc_hd__fill_1
* cell instance sky130_fd_sc_hd__fill_1_91 r0 *1 0,0
Xsky130_fd_sc_hd__fill_1_91 VSS VDD VDD sky130_fd_sc_hd__fill_1
* cell instance sky130_fd_sc_hd__fill_1_92 r0 *1 0,0
Xsky130_fd_sc_hd__fill_1_92 VSS VDD VDD sky130_fd_sc_hd__fill_1
* cell instance sky130_fd_sc_hd__fill_1_93 r0 *1 0,0
Xsky130_fd_sc_hd__fill_1_93 VSS VDD VDD sky130_fd_sc_hd__fill_1
* cell instance sky130_fd_sc_hd__fill_1_94 r0 *1 0,0
Xsky130_fd_sc_hd__fill_1_94 VSS VDD VDD sky130_fd_sc_hd__fill_1
* cell instance sky130_fd_sc_hd__fill_1_95 r0 *1 0,0
Xsky130_fd_sc_hd__fill_1_95 VSS VDD VDD sky130_fd_sc_hd__fill_1
* cell instance sky130_fd_sc_hd__fill_1_96 r0 *1 0,0
Xsky130_fd_sc_hd__fill_1_96 VSS VDD VDD sky130_fd_sc_hd__fill_1
* cell instance sky130_fd_sc_hd__fill_1_97 r0 *1 0,0
Xsky130_fd_sc_hd__fill_1_97 VSS VDD VDD sky130_fd_sc_hd__fill_1
* cell instance sky130_fd_sc_hd__fill_1_98 r0 *1 0,0
Xsky130_fd_sc_hd__fill_1_98 VSS VDD VDD sky130_fd_sc_hd__fill_1
* cell instance sky130_fd_sc_hd__fill_1_99 r0 *1 0,0
Xsky130_fd_sc_hd__fill_1_99 VSS VDD VDD sky130_fd_sc_hd__fill_1
* cell instance sky130_fd_sc_hd__fill_1_100 r0 *1 0,0
Xsky130_fd_sc_hd__fill_1_100 VSS VDD VDD sky130_fd_sc_hd__fill_1
* cell instance sky130_fd_sc_hd__fill_1_101 r0 *1 0,0
Xsky130_fd_sc_hd__fill_1_101 VSS VDD VDD sky130_fd_sc_hd__fill_1
* cell instance sky130_fd_sc_hd__fill_1_102 r0 *1 0,0
Xsky130_fd_sc_hd__fill_1_102 VSS VDD VDD sky130_fd_sc_hd__fill_1
* cell instance sky130_fd_sc_hd__fill_1_103 r0 *1 0,0
Xsky130_fd_sc_hd__fill_1_103 VSS VDD VDD sky130_fd_sc_hd__fill_1
* cell instance sky130_fd_sc_hd__fill_1_104 r0 *1 0,0
Xsky130_fd_sc_hd__fill_1_104 VSS VDD VDD sky130_fd_sc_hd__fill_1
* cell instance sky130_fd_sc_hd__fill_1_105 r0 *1 0,0
Xsky130_fd_sc_hd__fill_1_105 VSS VDD VDD sky130_fd_sc_hd__fill_1
* cell instance sky130_fd_sc_hd__fill_1_106 r0 *1 0,0
Xsky130_fd_sc_hd__fill_1_106 VSS VDD VDD sky130_fd_sc_hd__fill_1
* cell instance sky130_fd_sc_hd__fill_1_107 r0 *1 0,0
Xsky130_fd_sc_hd__fill_1_107 VSS VDD VDD sky130_fd_sc_hd__fill_1
* cell instance sky130_fd_sc_hd__fill_1_108 r0 *1 0,0
Xsky130_fd_sc_hd__fill_1_108 VSS VDD VDD sky130_fd_sc_hd__fill_1
* cell instance sky130_fd_sc_hd__fill_1_109 r0 *1 0,0
Xsky130_fd_sc_hd__fill_1_109 VSS VDD VDD sky130_fd_sc_hd__fill_1
* cell instance sky130_fd_sc_hd__fill_1_110 r0 *1 0,0
Xsky130_fd_sc_hd__fill_1_110 VSS VDD VDD sky130_fd_sc_hd__fill_1
* cell instance sky130_fd_sc_hd__fill_1_111 r0 *1 0,0
Xsky130_fd_sc_hd__fill_1_111 VSS VDD VDD sky130_fd_sc_hd__fill_1
* cell instance sky130_fd_sc_hd__fill_1_112 r0 *1 0,0
Xsky130_fd_sc_hd__fill_1_112 VSS VDD VDD sky130_fd_sc_hd__fill_1
* cell instance sky130_fd_sc_hd__fill_1_113 r0 *1 0,0
Xsky130_fd_sc_hd__fill_1_113 VSS VDD VDD sky130_fd_sc_hd__fill_1
* cell instance sky130_fd_sc_hd__fill_1_114 r0 *1 0,0
Xsky130_fd_sc_hd__fill_1_114 VSS VDD VDD sky130_fd_sc_hd__fill_1
* cell instance sky130_fd_sc_hd__fill_1_115 r0 *1 0,0
Xsky130_fd_sc_hd__fill_1_115 VSS VDD VDD sky130_fd_sc_hd__fill_1
* cell instance sky130_fd_sc_hd__fill_1_116 r0 *1 0,0
Xsky130_fd_sc_hd__fill_1_116 VSS VDD VDD sky130_fd_sc_hd__fill_1
* cell instance sky130_fd_sc_hd__fill_1_117 r0 *1 0,0
Xsky130_fd_sc_hd__fill_1_117 VSS VDD VDD sky130_fd_sc_hd__fill_1
* cell instance sky130_fd_sc_hd__fill_1_118 r0 *1 0,0
Xsky130_fd_sc_hd__fill_1_118 VSS VDD VDD sky130_fd_sc_hd__fill_1
* cell instance sky130_fd_sc_hd__fill_1_119 r0 *1 0,0
Xsky130_fd_sc_hd__fill_1_119 VSS VDD VDD sky130_fd_sc_hd__fill_1
* cell instance sky130_fd_sc_hd__fill_1_120 r0 *1 0,0
Xsky130_fd_sc_hd__fill_1_120 VSS VDD VDD sky130_fd_sc_hd__fill_1
* cell instance sky130_fd_sc_hd__fill_1_121 r0 *1 0,0
Xsky130_fd_sc_hd__fill_1_121 VSS VDD VDD sky130_fd_sc_hd__fill_1
* cell instance sky130_fd_sc_hd__fill_1_122 r0 *1 0,0
Xsky130_fd_sc_hd__fill_1_122 VSS VDD VDD sky130_fd_sc_hd__fill_1
* cell instance sky130_fd_sc_hd__fill_1_123 r0 *1 0,0
Xsky130_fd_sc_hd__fill_1_123 VSS VDD VDD sky130_fd_sc_hd__fill_1
* cell instance sky130_fd_sc_hd__fill_1_124 r0 *1 0,0
Xsky130_fd_sc_hd__fill_1_124 VSS VDD VDD sky130_fd_sc_hd__fill_1
* cell instance sky130_fd_sc_hd__fill_1_125 r0 *1 0,0
Xsky130_fd_sc_hd__fill_1_125 VSS VDD VDD sky130_fd_sc_hd__fill_1
* cell instance sky130_fd_sc_hd__fill_1_126 r0 *1 0,0
Xsky130_fd_sc_hd__fill_1_126 VSS VDD VDD sky130_fd_sc_hd__fill_1
* cell instance sky130_fd_sc_hd__fill_1_127 r0 *1 0,0
Xsky130_fd_sc_hd__fill_1_127 VSS VDD VDD sky130_fd_sc_hd__fill_1
* cell instance sky130_fd_sc_hd__fill_1_128 r0 *1 0,0
Xsky130_fd_sc_hd__fill_1_128 VSS VDD VDD sky130_fd_sc_hd__fill_1
* cell instance sky130_fd_sc_hd__fill_1_129 r0 *1 0,0
Xsky130_fd_sc_hd__fill_1_129 VSS VDD VDD sky130_fd_sc_hd__fill_1
* cell instance sky130_fd_sc_hd__fill_1_130 r0 *1 0,0
Xsky130_fd_sc_hd__fill_1_130 VSS VDD VDD sky130_fd_sc_hd__fill_1
* cell instance sky130_fd_sc_hd__fill_1_131 r0 *1 0,0
Xsky130_fd_sc_hd__fill_1_131 VSS VDD VDD sky130_fd_sc_hd__fill_1
* cell instance sky130_fd_sc_hd__fill_1_132 r0 *1 0,0
Xsky130_fd_sc_hd__fill_1_132 VSS VDD VDD sky130_fd_sc_hd__fill_1
* cell instance sky130_fd_sc_hd__fill_1_133 r0 *1 0,0
Xsky130_fd_sc_hd__fill_1_133 VSS VDD VDD sky130_fd_sc_hd__fill_1
* cell instance sky130_fd_sc_hd__fill_1_134 r0 *1 0,0
Xsky130_fd_sc_hd__fill_1_134 VSS VDD VDD sky130_fd_sc_hd__fill_1
* cell instance sky130_fd_sc_hd__fill_1_135 r0 *1 0,0
Xsky130_fd_sc_hd__fill_1_135 VSS VDD VDD sky130_fd_sc_hd__fill_1
* cell instance sky130_fd_sc_hd__fill_1_136 r0 *1 0,0
Xsky130_fd_sc_hd__fill_1_136 VSS VDD VDD sky130_fd_sc_hd__fill_1
* cell instance sky130_fd_sc_hd__fill_1_137 r0 *1 0,0
Xsky130_fd_sc_hd__fill_1_137 VSS VDD VDD sky130_fd_sc_hd__fill_1
* cell instance sky130_fd_sc_hd__fill_1_138 r0 *1 0,0
Xsky130_fd_sc_hd__fill_1_138 VSS VDD VDD sky130_fd_sc_hd__fill_1
* cell instance sky130_fd_sc_hd__fill_1_139 r0 *1 0,0
Xsky130_fd_sc_hd__fill_1_139 VSS VDD VDD sky130_fd_sc_hd__fill_1
* cell instance sky130_fd_sc_hd__fill_1_140 r0 *1 0,0
Xsky130_fd_sc_hd__fill_1_140 VSS VDD VDD sky130_fd_sc_hd__fill_1
* cell instance sky130_fd_sc_hd__fill_1_141 r0 *1 0,0
Xsky130_fd_sc_hd__fill_1_141 VSS VDD VDD sky130_fd_sc_hd__fill_1
* cell instance sky130_fd_sc_hd__fill_1_142 r0 *1 0,0
Xsky130_fd_sc_hd__fill_1_142 VSS VDD VDD sky130_fd_sc_hd__fill_1
* cell instance sky130_fd_sc_hd__fill_1_143 r0 *1 0,0
Xsky130_fd_sc_hd__fill_1_143 VSS VDD VDD sky130_fd_sc_hd__fill_1
* cell instance sky130_fd_sc_hd__fill_1_144 r0 *1 0,0
Xsky130_fd_sc_hd__fill_1_144 VSS VDD VDD sky130_fd_sc_hd__fill_1
* cell instance sky130_fd_sc_hd__fill_1_145 r0 *1 0,0
Xsky130_fd_sc_hd__fill_1_145 VSS VDD VDD sky130_fd_sc_hd__fill_1
* cell instance sky130_fd_sc_hd__fill_1_146 r0 *1 0,0
Xsky130_fd_sc_hd__fill_1_146 VSS VDD VDD sky130_fd_sc_hd__fill_1
* cell instance sky130_fd_sc_hd__fill_1_147 r0 *1 0,0
Xsky130_fd_sc_hd__fill_1_147 VSS VDD VDD sky130_fd_sc_hd__fill_1
* cell instance sky130_fd_sc_hd__fill_1_148 r0 *1 0,0
Xsky130_fd_sc_hd__fill_1_148 VSS VDD VDD sky130_fd_sc_hd__fill_1
* cell instance sky130_fd_sc_hd__fill_1_149 r0 *1 0,0
Xsky130_fd_sc_hd__fill_1_149 VSS VDD VDD sky130_fd_sc_hd__fill_1
* cell instance sky130_fd_sc_hd__fill_1_150 r0 *1 0,0
Xsky130_fd_sc_hd__fill_1_150 VSS VDD VDD sky130_fd_sc_hd__fill_1
* cell instance sky130_fd_sc_hd__fill_1_151 r0 *1 0,0
Xsky130_fd_sc_hd__fill_1_151 VSS VDD VDD sky130_fd_sc_hd__fill_1
* cell instance sky130_fd_sc_hd__fill_1_152 r0 *1 0,0
Xsky130_fd_sc_hd__fill_1_152 VSS VDD VDD sky130_fd_sc_hd__fill_1
* cell instance sky130_fd_sc_hd__fill_1_153 r0 *1 0,0
Xsky130_fd_sc_hd__fill_1_153 VSS VDD VDD sky130_fd_sc_hd__fill_1
* cell instance sky130_fd_sc_hd__fill_1_154 r0 *1 0,0
Xsky130_fd_sc_hd__fill_1_154 VSS VDD VDD sky130_fd_sc_hd__fill_1
* cell instance sky130_fd_sc_hd__fill_1_155 r0 *1 0,0
Xsky130_fd_sc_hd__fill_1_155 VSS VDD VDD sky130_fd_sc_hd__fill_1
* cell instance sky130_fd_sc_hd__fill_1_156 r0 *1 0,0
Xsky130_fd_sc_hd__fill_1_156 VSS VDD VDD sky130_fd_sc_hd__fill_1
* cell instance sky130_fd_sc_hd__fill_1_157 r0 *1 0,0
Xsky130_fd_sc_hd__fill_1_157 VSS VDD VDD sky130_fd_sc_hd__fill_1
* cell instance sky130_fd_sc_hd__fill_1_158 r0 *1 0,0
Xsky130_fd_sc_hd__fill_1_158 VSS VDD VDD sky130_fd_sc_hd__fill_1
* cell instance sky130_fd_sc_hd__fill_1_159 r0 *1 0,0
Xsky130_fd_sc_hd__fill_1_159 VSS VDD VDD sky130_fd_sc_hd__fill_1
* cell instance sky130_fd_sc_hd__fill_1_160 r0 *1 0,0
Xsky130_fd_sc_hd__fill_1_160 VSS VDD VDD sky130_fd_sc_hd__fill_1
* cell instance sky130_fd_sc_hd__fill_1_161 r0 *1 0,0
Xsky130_fd_sc_hd__fill_1_161 VSS VDD VDD sky130_fd_sc_hd__fill_1
* cell instance sky130_fd_sc_hd__fill_1_162 r0 *1 0,0
Xsky130_fd_sc_hd__fill_1_162 VSS VDD VDD sky130_fd_sc_hd__fill_1
* cell instance sky130_fd_sc_hd__fill_1_163 r0 *1 0,0
Xsky130_fd_sc_hd__fill_1_163 VSS VDD VDD sky130_fd_sc_hd__fill_1
* cell instance sky130_fd_sc_hd__fill_1_164 r0 *1 0,0
Xsky130_fd_sc_hd__fill_1_164 VSS VDD VDD sky130_fd_sc_hd__fill_1
* cell instance sky130_fd_sc_hd__fill_1_165 r0 *1 0,0
Xsky130_fd_sc_hd__fill_1_165 VSS VDD VDD sky130_fd_sc_hd__fill_1
* cell instance sky130_fd_sc_hd__fill_1_166 r0 *1 0,0
Xsky130_fd_sc_hd__fill_1_166 VSS VDD VDD sky130_fd_sc_hd__fill_1
* cell instance sky130_fd_sc_hd__fill_1_167 r0 *1 0,0
Xsky130_fd_sc_hd__fill_1_167 VSS VDD VDD sky130_fd_sc_hd__fill_1
* cell instance sky130_fd_sc_hd__fill_1_168 r0 *1 0,0
Xsky130_fd_sc_hd__fill_1_168 VSS VDD VDD sky130_fd_sc_hd__fill_1
* cell instance sky130_fd_sc_hd__fill_1_169 r0 *1 0,0
Xsky130_fd_sc_hd__fill_1_169 VSS VDD VDD sky130_fd_sc_hd__fill_1
* cell instance sky130_fd_sc_hd__fill_1_170 r0 *1 0,0
Xsky130_fd_sc_hd__fill_1_170 VSS VDD VDD sky130_fd_sc_hd__fill_1
* cell instance sky130_fd_sc_hd__fill_1_171 r0 *1 0,0
Xsky130_fd_sc_hd__fill_1_171 VSS VDD VDD sky130_fd_sc_hd__fill_1
* cell instance sky130_fd_sc_hd__fill_1_172 r0 *1 0,0
Xsky130_fd_sc_hd__fill_1_172 VSS VDD VDD sky130_fd_sc_hd__fill_1
* cell instance sky130_fd_sc_hd__fill_1_173 r0 *1 0,0
Xsky130_fd_sc_hd__fill_1_173 VSS VDD VDD sky130_fd_sc_hd__fill_1
* cell instance sky130_fd_sc_hd__fill_1_174 r0 *1 0,0
Xsky130_fd_sc_hd__fill_1_174 VSS VDD VDD sky130_fd_sc_hd__fill_1
* cell instance sky130_fd_sc_hd__fill_1_175 r0 *1 0,0
Xsky130_fd_sc_hd__fill_1_175 VSS VDD VDD sky130_fd_sc_hd__fill_1
* cell instance sky130_fd_sc_hd__fill_1_176 r0 *1 0,0
Xsky130_fd_sc_hd__fill_1_176 VSS VDD VDD sky130_fd_sc_hd__fill_1
* cell instance sky130_fd_sc_hd__fill_1_177 r0 *1 0,0
Xsky130_fd_sc_hd__fill_1_177 VSS VDD VDD sky130_fd_sc_hd__fill_1
* cell instance sky130_fd_sc_hd__fill_1_178 r0 *1 0,0
Xsky130_fd_sc_hd__fill_1_178 VSS VDD VDD sky130_fd_sc_hd__fill_1
* cell instance sky130_fd_sc_hd__fill_1_179 r0 *1 0,0
Xsky130_fd_sc_hd__fill_1_179 VSS VDD VDD sky130_fd_sc_hd__fill_1
* cell instance sky130_fd_sc_hd__fill_1_180 r0 *1 0,0
Xsky130_fd_sc_hd__fill_1_180 VSS VDD VDD sky130_fd_sc_hd__fill_1
* cell instance sky130_fd_sc_hd__fill_1_181 r0 *1 0,0
Xsky130_fd_sc_hd__fill_1_181 VSS VDD VDD sky130_fd_sc_hd__fill_1
* cell instance sky130_fd_sc_hd__fill_1_182 r0 *1 0,0
Xsky130_fd_sc_hd__fill_1_182 VSS VDD VDD sky130_fd_sc_hd__fill_1
* cell instance sky130_fd_sc_hd__fill_1_183 r0 *1 0,0
Xsky130_fd_sc_hd__fill_1_183 VSS VDD VDD sky130_fd_sc_hd__fill_1
* cell instance sky130_fd_sc_hd__fill_1_184 r0 *1 0,0
Xsky130_fd_sc_hd__fill_1_184 VSS VDD VDD sky130_fd_sc_hd__fill_1
* cell instance sky130_fd_sc_hd__fill_1_185 r0 *1 0,0
Xsky130_fd_sc_hd__fill_1_185 VSS VDD VDD sky130_fd_sc_hd__fill_1
* cell instance sky130_fd_sc_hd__fill_1_186 r0 *1 0,0
Xsky130_fd_sc_hd__fill_1_186 VSS VDD VDD sky130_fd_sc_hd__fill_1
* cell instance sky130_fd_sc_hd__fill_1_187 r0 *1 0,0
Xsky130_fd_sc_hd__fill_1_187 VSS VDD VDD sky130_fd_sc_hd__fill_1
* cell instance sky130_fd_sc_hd__fill_1_188 r0 *1 0,0
Xsky130_fd_sc_hd__fill_1_188 VSS VDD VDD sky130_fd_sc_hd__fill_1
* cell instance sky130_fd_sc_hd__fill_1_189 r0 *1 0,0
Xsky130_fd_sc_hd__fill_1_189 VSS VDD VDD sky130_fd_sc_hd__fill_1
* cell instance sky130_fd_sc_hd__fill_1_190 r0 *1 0,0
Xsky130_fd_sc_hd__fill_1_190 VSS VDD VDD sky130_fd_sc_hd__fill_1
* cell instance sky130_fd_sc_hd__fill_1_191 r0 *1 0,0
Xsky130_fd_sc_hd__fill_1_191 VSS VDD VDD sky130_fd_sc_hd__fill_1
* cell instance sky130_fd_sc_hd__fill_1_192 r0 *1 0,0
Xsky130_fd_sc_hd__fill_1_192 VSS VDD VDD sky130_fd_sc_hd__fill_1
* cell instance sky130_fd_sc_hd__fill_1_193 r0 *1 0,0
Xsky130_fd_sc_hd__fill_1_193 VSS VDD VDD sky130_fd_sc_hd__fill_1
* cell instance sky130_fd_sc_hd__fill_1_194 r0 *1 0,0
Xsky130_fd_sc_hd__fill_1_194 VSS VDD VDD sky130_fd_sc_hd__fill_1
* cell instance sky130_fd_sc_hd__fill_1_195 r0 *1 0,0
Xsky130_fd_sc_hd__fill_1_195 VSS VDD VDD sky130_fd_sc_hd__fill_1
* cell instance sky130_fd_sc_hd__fill_1_196 r0 *1 0,0
Xsky130_fd_sc_hd__fill_1_196 VSS VDD VDD sky130_fd_sc_hd__fill_1
* cell instance sky130_fd_sc_hd__fill_1_197 r0 *1 0,0
Xsky130_fd_sc_hd__fill_1_197 VSS VDD VDD sky130_fd_sc_hd__fill_1
* cell instance sky130_fd_sc_hd__fill_1_198 r0 *1 0,0
Xsky130_fd_sc_hd__fill_1_198 VSS VDD VDD sky130_fd_sc_hd__fill_1
* cell instance sky130_fd_sc_hd__fill_1_199 r0 *1 0,0
Xsky130_fd_sc_hd__fill_1_199 VSS VDD VDD sky130_fd_sc_hd__fill_1
* cell instance sky130_fd_sc_hd__fill_1_200 r0 *1 0,0
Xsky130_fd_sc_hd__fill_1_200 VSS VDD VDD sky130_fd_sc_hd__fill_1
* cell instance sky130_fd_sc_hd__fill_1_201 r0 *1 0,0
Xsky130_fd_sc_hd__fill_1_201 VSS VDD VDD sky130_fd_sc_hd__fill_1
* cell instance sky130_fd_sc_hd__fill_1_202 r0 *1 0,0
Xsky130_fd_sc_hd__fill_1_202 VSS VDD VDD sky130_fd_sc_hd__fill_1
* cell instance sky130_fd_sc_hd__fill_1_203 r0 *1 0,0
Xsky130_fd_sc_hd__fill_1_203 VSS VDD VDD sky130_fd_sc_hd__fill_1
* cell instance sky130_fd_sc_hd__fill_1_204 r0 *1 0,0
Xsky130_fd_sc_hd__fill_1_204 VSS VDD VDD sky130_fd_sc_hd__fill_1
* cell instance sky130_fd_sc_hd__fill_1_205 r0 *1 0,0
Xsky130_fd_sc_hd__fill_1_205 VSS VDD VDD sky130_fd_sc_hd__fill_1
* cell instance sky130_fd_sc_hd__fill_1_206 r0 *1 0,0
Xsky130_fd_sc_hd__fill_1_206 VSS VDD VDD sky130_fd_sc_hd__fill_1
* cell instance sky130_fd_sc_hd__fill_1_207 r0 *1 0,0
Xsky130_fd_sc_hd__fill_1_207 VSS VDD VDD sky130_fd_sc_hd__fill_1
* cell instance sky130_fd_sc_hd__fill_1_208 r0 *1 0,0
Xsky130_fd_sc_hd__fill_1_208 VSS VDD VDD sky130_fd_sc_hd__fill_1
* cell instance sky130_fd_sc_hd__fill_1_209 r0 *1 0,0
Xsky130_fd_sc_hd__fill_1_209 VSS VDD VDD sky130_fd_sc_hd__fill_1
* cell instance sky130_fd_sc_hd__fill_1_210 r0 *1 0,0
Xsky130_fd_sc_hd__fill_1_210 VSS VDD VDD sky130_fd_sc_hd__fill_1
* cell instance sky130_fd_sc_hd__fill_1_211 r0 *1 0,0
Xsky130_fd_sc_hd__fill_1_211 VSS VDD VDD sky130_fd_sc_hd__fill_1
* cell instance sky130_fd_sc_hd__fill_1_212 r0 *1 0,0
Xsky130_fd_sc_hd__fill_1_212 VSS VDD VDD sky130_fd_sc_hd__fill_1
* cell instance sky130_fd_sc_hd__fill_1_213 r0 *1 0,0
Xsky130_fd_sc_hd__fill_1_213 VSS VDD VDD sky130_fd_sc_hd__fill_1
* cell instance sky130_fd_sc_hd__fill_1_214 r0 *1 0,0
Xsky130_fd_sc_hd__fill_1_214 VSS VDD VDD sky130_fd_sc_hd__fill_1
* cell instance sky130_fd_sc_hd__fill_1_215 r0 *1 0,0
Xsky130_fd_sc_hd__fill_1_215 VSS VDD VDD sky130_fd_sc_hd__fill_1
* cell instance sky130_fd_sc_hd__fill_1_216 r0 *1 0,0
Xsky130_fd_sc_hd__fill_1_216 VSS VDD VDD sky130_fd_sc_hd__fill_1
* cell instance sky130_fd_sc_hd__fill_1_217 r0 *1 0,0
Xsky130_fd_sc_hd__fill_1_217 VSS VDD VDD sky130_fd_sc_hd__fill_1
* cell instance sky130_fd_sc_hd__fill_1_218 r0 *1 0,0
Xsky130_fd_sc_hd__fill_1_218 VSS VDD VDD sky130_fd_sc_hd__fill_1
* cell instance sky130_fd_sc_hd__fill_1_219 r0 *1 0,0
Xsky130_fd_sc_hd__fill_1_219 VSS VDD VDD sky130_fd_sc_hd__fill_1
* cell instance sky130_fd_sc_hd__fill_1_220 r0 *1 0,0
Xsky130_fd_sc_hd__fill_1_220 VSS VDD VDD sky130_fd_sc_hd__fill_1
* cell instance sky130_fd_sc_hd__fill_1_221 r0 *1 0,0
Xsky130_fd_sc_hd__fill_1_221 VSS VDD VDD sky130_fd_sc_hd__fill_1
* cell instance sky130_fd_sc_hd__fill_1_222 r0 *1 0,0
Xsky130_fd_sc_hd__fill_1_222 VSS VDD VDD sky130_fd_sc_hd__fill_1
* cell instance sky130_fd_sc_hd__fill_1_223 r0 *1 0,0
Xsky130_fd_sc_hd__fill_1_223 VSS VDD VDD sky130_fd_sc_hd__fill_1
* cell instance sky130_fd_sc_hd__fill_1_224 r0 *1 0,0
Xsky130_fd_sc_hd__fill_1_224 VSS VDD VDD sky130_fd_sc_hd__fill_1
* cell instance sky130_fd_sc_hd__fill_1_225 r0 *1 0,0
Xsky130_fd_sc_hd__fill_1_225 VSS VDD VDD sky130_fd_sc_hd__fill_1
* cell instance sky130_fd_sc_hd__fill_1_226 r0 *1 0,0
Xsky130_fd_sc_hd__fill_1_226 VSS VDD VDD sky130_fd_sc_hd__fill_1
* cell instance sky130_fd_sc_hd__fill_1_227 r0 *1 0,0
Xsky130_fd_sc_hd__fill_1_227 VSS VDD VDD sky130_fd_sc_hd__fill_1
* cell instance sky130_fd_sc_hd__fill_1_228 r0 *1 0,0
Xsky130_fd_sc_hd__fill_1_228 VSS VDD VDD sky130_fd_sc_hd__fill_1
* cell instance sky130_fd_sc_hd__fill_1_229 r0 *1 0,0
Xsky130_fd_sc_hd__fill_1_229 VSS VDD VDD sky130_fd_sc_hd__fill_1
* cell instance sky130_fd_sc_hd__fill_1_230 r0 *1 0,0
Xsky130_fd_sc_hd__fill_1_230 VSS VDD VDD sky130_fd_sc_hd__fill_1
* cell instance sky130_fd_sc_hd__fill_1_231 r0 *1 0,0
Xsky130_fd_sc_hd__fill_1_231 VSS VDD VDD sky130_fd_sc_hd__fill_1
* cell instance sky130_fd_sc_hd__fill_1_232 r0 *1 0,0
Xsky130_fd_sc_hd__fill_1_232 VSS VDD VDD sky130_fd_sc_hd__fill_1
* cell instance sky130_fd_sc_hd__fill_1_233 r0 *1 0,0
Xsky130_fd_sc_hd__fill_1_233 VSS VDD VDD sky130_fd_sc_hd__fill_1
* cell instance sky130_fd_sc_hd__fill_1_234 r0 *1 0,0
Xsky130_fd_sc_hd__fill_1_234 VSS VDD VDD sky130_fd_sc_hd__fill_1
* cell instance sky130_fd_sc_hd__fill_1_235 r0 *1 0,0
Xsky130_fd_sc_hd__fill_1_235 VSS VDD VDD sky130_fd_sc_hd__fill_1
* cell instance sky130_fd_sc_hd__fill_1_236 r0 *1 0,0
Xsky130_fd_sc_hd__fill_1_236 VSS VDD VDD sky130_fd_sc_hd__fill_1
* cell instance sky130_fd_sc_hd__fill_1_237 r0 *1 0,0
Xsky130_fd_sc_hd__fill_1_237 VSS VDD VDD sky130_fd_sc_hd__fill_1
* cell instance sky130_fd_sc_hd__fill_1_238 r0 *1 0,0
Xsky130_fd_sc_hd__fill_1_238 VSS VDD VDD sky130_fd_sc_hd__fill_1
* cell instance sky130_fd_sc_hd__fill_1_239 r0 *1 0,0
Xsky130_fd_sc_hd__fill_1_239 VSS VDD VDD sky130_fd_sc_hd__fill_1
* cell instance sky130_fd_sc_hd__fill_1_240 r0 *1 0,0
Xsky130_fd_sc_hd__fill_1_240 VSS VDD VDD sky130_fd_sc_hd__fill_1
* cell instance sky130_fd_sc_hd__fill_1_241 r0 *1 0,0
Xsky130_fd_sc_hd__fill_1_241 VSS VDD VDD sky130_fd_sc_hd__fill_1
* cell instance sky130_fd_sc_hd__fill_1_242 r0 *1 0,0
Xsky130_fd_sc_hd__fill_1_242 VSS VDD VDD sky130_fd_sc_hd__fill_1
* cell instance sky130_fd_sc_hd__fill_1_243 r0 *1 0,0
Xsky130_fd_sc_hd__fill_1_243 VSS VDD VDD sky130_fd_sc_hd__fill_1
* cell instance sky130_fd_sc_hd__fill_1_244 r0 *1 0,0
Xsky130_fd_sc_hd__fill_1_244 VSS VDD VDD sky130_fd_sc_hd__fill_1
* cell instance sky130_fd_sc_hd__fill_1_245 r0 *1 0,0
Xsky130_fd_sc_hd__fill_1_245 VSS VDD VDD sky130_fd_sc_hd__fill_1
* cell instance sky130_fd_sc_hd__fill_1_246 r0 *1 0,0
Xsky130_fd_sc_hd__fill_1_246 VSS VDD VDD sky130_fd_sc_hd__fill_1
* cell instance sky130_fd_sc_hd__fill_1_247 r0 *1 0,0
Xsky130_fd_sc_hd__fill_1_247 VSS VDD VDD sky130_fd_sc_hd__fill_1
* cell instance sky130_fd_sc_hd__fill_1_248 r0 *1 0,0
Xsky130_fd_sc_hd__fill_1_248 VSS VDD VDD sky130_fd_sc_hd__fill_1
* cell instance sky130_fd_sc_hd__fill_1_249 r0 *1 0,0
Xsky130_fd_sc_hd__fill_1_249 VSS VDD VDD sky130_fd_sc_hd__fill_1
* cell instance sky130_fd_sc_hd__fill_1_250 r0 *1 0,0
Xsky130_fd_sc_hd__fill_1_250 VSS VDD VDD sky130_fd_sc_hd__fill_1
* cell instance sky130_fd_sc_hd__fill_1_251 r0 *1 0,0
Xsky130_fd_sc_hd__fill_1_251 VSS VDD VDD sky130_fd_sc_hd__fill_1
* cell instance sky130_fd_sc_hd__fill_1_252 r0 *1 0,0
Xsky130_fd_sc_hd__fill_1_252 VSS VDD VDD sky130_fd_sc_hd__fill_1
* cell instance sky130_fd_sc_hd__fill_1_253 r0 *1 0,0
Xsky130_fd_sc_hd__fill_1_253 VSS VDD VDD sky130_fd_sc_hd__fill_1
* cell instance sky130_fd_sc_hd__fill_1_254 r0 *1 0,0
Xsky130_fd_sc_hd__fill_1_254 VSS VDD VDD sky130_fd_sc_hd__fill_1
* cell instance sky130_fd_sc_hd__fill_1_255 r0 *1 0,0
Xsky130_fd_sc_hd__fill_1_255 VSS VDD VDD sky130_fd_sc_hd__fill_1
* cell instance sky130_fd_sc_hd__fill_1_256 r0 *1 0,0
Xsky130_fd_sc_hd__fill_1_256 VSS VDD VDD sky130_fd_sc_hd__fill_1
* cell instance sky130_fd_sc_hd__fill_1_257 r0 *1 0,0
Xsky130_fd_sc_hd__fill_1_257 VSS VDD VDD sky130_fd_sc_hd__fill_1
* cell instance sky130_fd_sc_hd__fill_1_258 r0 *1 0,0
Xsky130_fd_sc_hd__fill_1_258 VSS VDD VDD sky130_fd_sc_hd__fill_1
* cell instance sky130_fd_sc_hd__fill_1_259 r0 *1 0,0
Xsky130_fd_sc_hd__fill_1_259 VSS VDD VDD sky130_fd_sc_hd__fill_1
* cell instance sky130_fd_sc_hd__fill_1_260 r0 *1 0,0
Xsky130_fd_sc_hd__fill_1_260 VSS VDD VDD sky130_fd_sc_hd__fill_1
* cell instance sky130_fd_sc_hd__fill_1_261 r0 *1 0,0
Xsky130_fd_sc_hd__fill_1_261 VSS VDD VDD sky130_fd_sc_hd__fill_1
* cell instance sky130_fd_sc_hd__fill_1_262 r0 *1 0,0
Xsky130_fd_sc_hd__fill_1_262 VSS VDD VDD sky130_fd_sc_hd__fill_1
* cell instance sky130_fd_sc_hd__fill_1_263 r0 *1 0,0
Xsky130_fd_sc_hd__fill_1_263 VSS VDD VDD sky130_fd_sc_hd__fill_1
* cell instance sky130_fd_sc_hd__fill_1_264 r0 *1 0,0
Xsky130_fd_sc_hd__fill_1_264 VSS VDD VDD sky130_fd_sc_hd__fill_1
* cell instance sky130_fd_sc_hd__fill_1_265 r0 *1 0,0
Xsky130_fd_sc_hd__fill_1_265 VSS VDD VDD sky130_fd_sc_hd__fill_1
* cell instance sky130_fd_sc_hd__fill_1_266 r0 *1 0,0
Xsky130_fd_sc_hd__fill_1_266 VSS VDD VDD sky130_fd_sc_hd__fill_1
* cell instance sky130_fd_sc_hd__fill_1_267 r0 *1 0,0
Xsky130_fd_sc_hd__fill_1_267 VSS VDD VDD sky130_fd_sc_hd__fill_1
* cell instance sky130_fd_sc_hd__fill_1_268 r0 *1 0,0
Xsky130_fd_sc_hd__fill_1_268 VSS VDD VDD sky130_fd_sc_hd__fill_1
* cell instance sky130_fd_sc_hd__fill_1_269 r0 *1 0,0
Xsky130_fd_sc_hd__fill_1_269 VSS VDD VDD sky130_fd_sc_hd__fill_1
* cell instance sky130_fd_sc_hd__fill_1_270 r0 *1 0,0
Xsky130_fd_sc_hd__fill_1_270 VSS VDD VDD sky130_fd_sc_hd__fill_1
* cell instance sky130_fd_sc_hd__fill_1_271 r0 *1 0,0
Xsky130_fd_sc_hd__fill_1_271 VSS VDD VDD sky130_fd_sc_hd__fill_1
* cell instance sky130_fd_sc_hd__fill_1_272 r0 *1 0,0
Xsky130_fd_sc_hd__fill_1_272 VSS VDD VDD sky130_fd_sc_hd__fill_1
* cell instance sky130_fd_sc_hd__fill_1_273 r0 *1 0,0
Xsky130_fd_sc_hd__fill_1_273 VSS VDD VDD sky130_fd_sc_hd__fill_1
* cell instance sky130_fd_sc_hd__fill_1_274 r0 *1 0,0
Xsky130_fd_sc_hd__fill_1_274 VSS VDD VDD sky130_fd_sc_hd__fill_1
* cell instance sky130_fd_sc_hd__fill_1_275 r0 *1 0,0
Xsky130_fd_sc_hd__fill_1_275 VSS VDD VDD sky130_fd_sc_hd__fill_1
* cell instance sky130_fd_sc_hd__fill_1_276 r0 *1 0,0
Xsky130_fd_sc_hd__fill_1_276 VSS VDD VDD sky130_fd_sc_hd__fill_1
* cell instance sky130_fd_sc_hd__fill_1_277 r0 *1 0,0
Xsky130_fd_sc_hd__fill_1_277 VSS VDD VDD sky130_fd_sc_hd__fill_1
* cell instance sky130_fd_sc_hd__fill_1_278 r0 *1 0,0
Xsky130_fd_sc_hd__fill_1_278 VSS VDD VDD sky130_fd_sc_hd__fill_1
* cell instance sky130_fd_sc_hd__fill_1_279 r0 *1 0,0
Xsky130_fd_sc_hd__fill_1_279 VSS VDD VDD sky130_fd_sc_hd__fill_1
* cell instance sky130_fd_sc_hd__fill_1_280 r0 *1 0,0
Xsky130_fd_sc_hd__fill_1_280 VSS VDD VDD sky130_fd_sc_hd__fill_1
* cell instance sky130_fd_sc_hd__fill_1_281 r0 *1 0,0
Xsky130_fd_sc_hd__fill_1_281 VSS VDD VDD sky130_fd_sc_hd__fill_1
* cell instance sky130_fd_sc_hd__fill_1_282 r0 *1 0,0
Xsky130_fd_sc_hd__fill_1_282 VSS VDD VDD sky130_fd_sc_hd__fill_1
* cell instance sky130_fd_sc_hd__fill_1_283 r0 *1 0,0
Xsky130_fd_sc_hd__fill_1_283 VSS VDD VDD sky130_fd_sc_hd__fill_1
* cell instance sky130_fd_sc_hd__fill_1_284 r0 *1 0,0
Xsky130_fd_sc_hd__fill_1_284 VSS VDD VDD sky130_fd_sc_hd__fill_1
* cell instance sky130_fd_sc_hd__fill_1_285 r0 *1 0,0
Xsky130_fd_sc_hd__fill_1_285 VSS VDD VDD sky130_fd_sc_hd__fill_1
* cell instance sky130_fd_sc_hd__fill_1_286 r0 *1 0,0
Xsky130_fd_sc_hd__fill_1_286 VSS VDD VDD sky130_fd_sc_hd__fill_1
* cell instance sky130_fd_sc_hd__fill_1_287 r0 *1 0,0
Xsky130_fd_sc_hd__fill_1_287 VSS VDD VDD sky130_fd_sc_hd__fill_1
* cell instance sky130_fd_sc_hd__fill_1_288 r0 *1 0,0
Xsky130_fd_sc_hd__fill_1_288 VSS VDD VDD sky130_fd_sc_hd__fill_1
* cell instance sky130_fd_sc_hd__fill_1_289 r0 *1 0,0
Xsky130_fd_sc_hd__fill_1_289 VSS VDD VDD sky130_fd_sc_hd__fill_1
* cell instance sky130_fd_sc_hd__fill_1_290 r0 *1 0,0
Xsky130_fd_sc_hd__fill_1_290 VSS VDD VDD sky130_fd_sc_hd__fill_1
* cell instance sky130_fd_sc_hd__fill_1_291 r0 *1 0,0
Xsky130_fd_sc_hd__fill_1_291 VSS VDD VDD sky130_fd_sc_hd__fill_1
* cell instance sky130_fd_sc_hd__fill_1_292 r0 *1 0,0
Xsky130_fd_sc_hd__fill_1_292 VSS VDD VDD sky130_fd_sc_hd__fill_1
* cell instance sky130_fd_sc_hd__fill_1_293 r0 *1 0,0
Xsky130_fd_sc_hd__fill_1_293 VSS VDD VDD sky130_fd_sc_hd__fill_1
* cell instance sky130_fd_sc_hd__fill_1_294 r0 *1 0,0
Xsky130_fd_sc_hd__fill_1_294 VSS VDD VDD sky130_fd_sc_hd__fill_1
* cell instance sky130_fd_sc_hd__fill_1_295 r0 *1 0,0
Xsky130_fd_sc_hd__fill_1_295 VSS VDD VDD sky130_fd_sc_hd__fill_1
* cell instance sky130_fd_sc_hd__fill_1_296 r0 *1 0,0
Xsky130_fd_sc_hd__fill_1_296 VSS VDD VDD sky130_fd_sc_hd__fill_1
* cell instance sky130_fd_sc_hd__fill_1_297 r0 *1 0,0
Xsky130_fd_sc_hd__fill_1_297 VSS VDD VDD sky130_fd_sc_hd__fill_1
* cell instance sky130_fd_sc_hd__fill_1_298 r0 *1 0,0
Xsky130_fd_sc_hd__fill_1_298 VSS VDD VDD sky130_fd_sc_hd__fill_1
* cell instance sky130_fd_sc_hd__fill_1_299 r0 *1 0,0
Xsky130_fd_sc_hd__fill_1_299 VSS VDD VDD sky130_fd_sc_hd__fill_1
* cell instance sky130_fd_sc_hd__fill_1_300 r0 *1 0,0
Xsky130_fd_sc_hd__fill_1_300 VSS VDD VDD sky130_fd_sc_hd__fill_1
* cell instance sky130_fd_sc_hd__fill_1_301 r0 *1 0,0
Xsky130_fd_sc_hd__fill_1_301 VSS VDD VDD sky130_fd_sc_hd__fill_1
* cell instance sky130_fd_sc_hd__fill_1_302 r0 *1 0,0
Xsky130_fd_sc_hd__fill_1_302 VSS VDD VDD sky130_fd_sc_hd__fill_1
* cell instance sky130_fd_sc_hd__fill_1_303 r0 *1 0,0
Xsky130_fd_sc_hd__fill_1_303 VSS VDD VDD sky130_fd_sc_hd__fill_1
* cell instance sky130_fd_sc_hd__fill_1_304 r0 *1 0,0
Xsky130_fd_sc_hd__fill_1_304 VSS VDD VDD sky130_fd_sc_hd__fill_1
* cell instance sky130_fd_sc_hd__fill_1_305 r0 *1 0,0
Xsky130_fd_sc_hd__fill_1_305 VSS VDD VDD sky130_fd_sc_hd__fill_1
* cell instance sky130_fd_sc_hd__fill_1_306 r0 *1 0,0
Xsky130_fd_sc_hd__fill_1_306 VSS VDD VDD sky130_fd_sc_hd__fill_1
* cell instance sky130_fd_sc_hd__fill_1_307 r0 *1 0,0
Xsky130_fd_sc_hd__fill_1_307 VSS VDD VDD sky130_fd_sc_hd__fill_1
* cell instance sky130_fd_sc_hd__fill_1_308 r0 *1 0,0
Xsky130_fd_sc_hd__fill_1_308 VSS VDD VDD sky130_fd_sc_hd__fill_1
* cell instance sky130_fd_sc_hd__fill_1_309 r0 *1 0,0
Xsky130_fd_sc_hd__fill_1_309 VSS VDD VDD sky130_fd_sc_hd__fill_1
* cell instance sky130_fd_sc_hd__fill_1_310 r0 *1 0,0
Xsky130_fd_sc_hd__fill_1_310 VSS VDD VDD sky130_fd_sc_hd__fill_1
* cell instance sky130_fd_sc_hd__fill_1_311 r0 *1 0,0
Xsky130_fd_sc_hd__fill_1_311 VSS VDD VDD sky130_fd_sc_hd__fill_1
* cell instance sky130_fd_sc_hd__fill_1_312 r0 *1 0,0
Xsky130_fd_sc_hd__fill_1_312 VSS VDD VDD sky130_fd_sc_hd__fill_1
* cell instance sky130_fd_sc_hd__fill_1_313 r0 *1 0,0
Xsky130_fd_sc_hd__fill_1_313 VSS VDD VDD sky130_fd_sc_hd__fill_1
* cell instance sky130_fd_sc_hd__fill_1_314 r0 *1 0,0
Xsky130_fd_sc_hd__fill_1_314 VSS VDD VDD sky130_fd_sc_hd__fill_1
* cell instance sky130_fd_sc_hd__fill_1_315 r0 *1 0,0
Xsky130_fd_sc_hd__fill_1_315 VSS VDD VDD sky130_fd_sc_hd__fill_1
* cell instance sky130_fd_sc_hd__fill_1_316 r0 *1 0,0
Xsky130_fd_sc_hd__fill_1_316 VSS VDD VDD sky130_fd_sc_hd__fill_1
* cell instance sky130_fd_sc_hd__fill_1_317 r0 *1 0,0
Xsky130_fd_sc_hd__fill_1_317 VSS VDD VDD sky130_fd_sc_hd__fill_1
* cell instance sky130_fd_sc_hd__fill_1_318 r0 *1 0,0
Xsky130_fd_sc_hd__fill_1_318 VSS VDD VDD sky130_fd_sc_hd__fill_1
* cell instance sky130_fd_sc_hd__fill_1_319 r0 *1 0,0
Xsky130_fd_sc_hd__fill_1_319 VSS VDD VDD sky130_fd_sc_hd__fill_1
* cell instance sky130_fd_sc_hd__fill_1_320 r0 *1 0,0
Xsky130_fd_sc_hd__fill_1_320 VSS VDD VDD sky130_fd_sc_hd__fill_1
* cell instance sky130_fd_sc_hd__fill_1_321 r0 *1 0,0
Xsky130_fd_sc_hd__fill_1_321 VSS VDD VDD sky130_fd_sc_hd__fill_1
* cell instance sky130_fd_sc_hd__fill_1_322 r0 *1 0,0
Xsky130_fd_sc_hd__fill_1_322 VSS VDD VDD sky130_fd_sc_hd__fill_1
* cell instance sky130_fd_sc_hd__fill_1_323 r0 *1 0,0
Xsky130_fd_sc_hd__fill_1_323 VSS VDD VDD sky130_fd_sc_hd__fill_1
* cell instance sky130_fd_sc_hd__fill_1_324 r0 *1 0,0
Xsky130_fd_sc_hd__fill_1_324 VSS VDD VDD sky130_fd_sc_hd__fill_1
* cell instance sky130_fd_sc_hd__fill_1_325 r0 *1 0,0
Xsky130_fd_sc_hd__fill_1_325 VSS VDD VDD sky130_fd_sc_hd__fill_1
* cell instance sky130_fd_sc_hd__fill_1_326 r0 *1 0,0
Xsky130_fd_sc_hd__fill_1_326 VSS VDD VDD sky130_fd_sc_hd__fill_1
* cell instance sky130_fd_sc_hd__fill_1_327 r0 *1 0,0
Xsky130_fd_sc_hd__fill_1_327 VSS VDD VDD sky130_fd_sc_hd__fill_1
* cell instance sky130_fd_sc_hd__fill_1_328 r0 *1 0,0
Xsky130_fd_sc_hd__fill_1_328 VSS VDD VDD sky130_fd_sc_hd__fill_1
* cell instance sky130_fd_sc_hd__fill_1_329 r0 *1 0,0
Xsky130_fd_sc_hd__fill_1_329 VSS VDD VDD sky130_fd_sc_hd__fill_1
* cell instance sky130_fd_sc_hd__fill_1_330 r0 *1 0,0
Xsky130_fd_sc_hd__fill_1_330 VSS VDD VDD sky130_fd_sc_hd__fill_1
* cell instance sky130_fd_sc_hd__fill_1_331 r0 *1 0,0
Xsky130_fd_sc_hd__fill_1_331 VSS VDD VDD sky130_fd_sc_hd__fill_1
* cell instance sky130_fd_sc_hd__fill_1_332 r0 *1 0,0
Xsky130_fd_sc_hd__fill_1_332 VSS VDD VDD sky130_fd_sc_hd__fill_1
* cell instance sky130_fd_sc_hd__fill_1_333 r0 *1 0,0
Xsky130_fd_sc_hd__fill_1_333 VSS VDD VDD sky130_fd_sc_hd__fill_1
* cell instance sky130_fd_sc_hd__fill_1_334 r0 *1 0,0
Xsky130_fd_sc_hd__fill_1_334 VSS VDD VDD sky130_fd_sc_hd__fill_1
* cell instance sky130_fd_sc_hd__fill_1_335 r0 *1 0,0
Xsky130_fd_sc_hd__fill_1_335 VSS VDD VDD sky130_fd_sc_hd__fill_1
* cell instance sky130_fd_sc_hd__fill_1_336 r0 *1 0,0
Xsky130_fd_sc_hd__fill_1_336 VSS VDD VDD sky130_fd_sc_hd__fill_1
* cell instance sky130_fd_sc_hd__fill_1_337 r0 *1 0,0
Xsky130_fd_sc_hd__fill_1_337 VSS VDD VDD sky130_fd_sc_hd__fill_1
* cell instance sky130_fd_sc_hd__fill_1_338 r0 *1 0,0
Xsky130_fd_sc_hd__fill_1_338 VSS VDD VDD sky130_fd_sc_hd__fill_1
* cell instance sky130_fd_sc_hd__fill_1_339 r0 *1 0,0
Xsky130_fd_sc_hd__fill_1_339 VSS VDD VDD sky130_fd_sc_hd__fill_1
* cell instance sky130_fd_sc_hd__fill_1_340 r0 *1 0,0
Xsky130_fd_sc_hd__fill_1_340 VSS VDD VDD sky130_fd_sc_hd__fill_1
* cell instance sky130_fd_sc_hd__fill_1_341 r0 *1 0,0
Xsky130_fd_sc_hd__fill_1_341 VSS VDD VDD sky130_fd_sc_hd__fill_1
* cell instance sky130_fd_sc_hd__fill_1_342 r0 *1 0,0
Xsky130_fd_sc_hd__fill_1_342 VSS VDD VDD sky130_fd_sc_hd__fill_1
* cell instance sky130_fd_sc_hd__fill_1_343 r0 *1 0,0
Xsky130_fd_sc_hd__fill_1_343 VSS VDD VDD sky130_fd_sc_hd__fill_1
* cell instance sky130_fd_sc_hd__fill_1_344 r0 *1 0,0
Xsky130_fd_sc_hd__fill_1_344 VSS VDD VDD sky130_fd_sc_hd__fill_1
* cell instance sky130_fd_sc_hd__fill_1_345 r0 *1 0,0
Xsky130_fd_sc_hd__fill_1_345 VSS VDD VDD sky130_fd_sc_hd__fill_1
* cell instance sky130_fd_sc_hd__fill_1_346 r0 *1 0,0
Xsky130_fd_sc_hd__fill_1_346 VSS VDD VDD sky130_fd_sc_hd__fill_1
* cell instance sky130_fd_sc_hd__fill_1_347 r0 *1 0,0
Xsky130_fd_sc_hd__fill_1_347 VSS VDD VDD sky130_fd_sc_hd__fill_1
* cell instance sky130_fd_sc_hd__fill_1_348 r0 *1 0,0
Xsky130_fd_sc_hd__fill_1_348 VSS VDD VDD sky130_fd_sc_hd__fill_1
* cell instance sky130_fd_sc_hd__fill_1_349 r0 *1 0,0
Xsky130_fd_sc_hd__fill_1_349 VSS VDD VDD sky130_fd_sc_hd__fill_1
* cell instance sky130_fd_sc_hd__fill_1_350 r0 *1 0,0
Xsky130_fd_sc_hd__fill_1_350 VSS VDD VDD sky130_fd_sc_hd__fill_1
* cell instance sky130_fd_sc_hd__fill_1_351 r0 *1 0,0
Xsky130_fd_sc_hd__fill_1_351 VSS VDD VDD sky130_fd_sc_hd__fill_1
* cell instance sky130_fd_sc_hd__fill_1_352 r0 *1 0,0
Xsky130_fd_sc_hd__fill_1_352 VSS VDD VDD sky130_fd_sc_hd__fill_1
* cell instance sky130_fd_sc_hd__fill_1_353 r0 *1 0,0
Xsky130_fd_sc_hd__fill_1_353 VSS VDD VDD sky130_fd_sc_hd__fill_1
* cell instance sky130_fd_sc_hd__fill_1_354 r0 *1 0,0
Xsky130_fd_sc_hd__fill_1_354 VSS VDD VDD sky130_fd_sc_hd__fill_1
* cell instance sky130_fd_sc_hd__fill_1_355 r0 *1 0,0
Xsky130_fd_sc_hd__fill_1_355 VSS VDD VDD sky130_fd_sc_hd__fill_1
* cell instance sky130_fd_sc_hd__fill_1_356 r0 *1 0,0
Xsky130_fd_sc_hd__fill_1_356 VSS VDD VDD sky130_fd_sc_hd__fill_1
* cell instance sky130_fd_sc_hd__fill_1_357 r0 *1 0,0
Xsky130_fd_sc_hd__fill_1_357 VSS VDD VDD sky130_fd_sc_hd__fill_1
* cell instance sky130_fd_sc_hd__fill_1_358 r0 *1 0,0
Xsky130_fd_sc_hd__fill_1_358 VSS VDD VDD sky130_fd_sc_hd__fill_1
* cell instance sky130_fd_sc_hd__fill_1_359 r0 *1 0,0
Xsky130_fd_sc_hd__fill_1_359 VSS VDD VDD sky130_fd_sc_hd__fill_1
* cell instance sky130_fd_sc_hd__fill_1_360 r0 *1 0,0
Xsky130_fd_sc_hd__fill_1_360 VSS VDD VDD sky130_fd_sc_hd__fill_1
* cell instance sky130_fd_sc_hd__fill_1_361 r0 *1 0,0
Xsky130_fd_sc_hd__fill_1_361 VSS VDD VDD sky130_fd_sc_hd__fill_1
* cell instance sky130_fd_sc_hd__fill_1_362 r0 *1 0,0
Xsky130_fd_sc_hd__fill_1_362 VSS VDD VDD sky130_fd_sc_hd__fill_1
* cell instance sky130_fd_sc_hd__fill_1_363 r0 *1 0,0
Xsky130_fd_sc_hd__fill_1_363 VSS VDD VDD sky130_fd_sc_hd__fill_1
* cell instance sky130_fd_sc_hd__fill_1_364 r0 *1 0,0
Xsky130_fd_sc_hd__fill_1_364 VSS VDD VDD sky130_fd_sc_hd__fill_1
* cell instance sky130_fd_sc_hd__fill_1_365 r0 *1 0,0
Xsky130_fd_sc_hd__fill_1_365 VSS VDD VDD sky130_fd_sc_hd__fill_1
* cell instance sky130_fd_sc_hd__fill_1_366 r0 *1 0,0
Xsky130_fd_sc_hd__fill_1_366 VSS VDD VDD sky130_fd_sc_hd__fill_1
* cell instance sky130_fd_sc_hd__fill_1_367 r0 *1 0,0
Xsky130_fd_sc_hd__fill_1_367 VSS VDD VDD sky130_fd_sc_hd__fill_1
* cell instance sky130_fd_sc_hd__fill_1_368 r0 *1 0,0
Xsky130_fd_sc_hd__fill_1_368 VSS VDD VDD sky130_fd_sc_hd__fill_1
* cell instance sky130_fd_sc_hd__fill_1_369 r0 *1 0,0
Xsky130_fd_sc_hd__fill_1_369 VSS VDD VDD sky130_fd_sc_hd__fill_1
* cell instance sky130_fd_sc_hd__fill_1_370 r0 *1 0,0
Xsky130_fd_sc_hd__fill_1_370 VSS VDD VDD sky130_fd_sc_hd__fill_1
* cell instance sky130_fd_sc_hd__fill_1_371 r0 *1 0,0
Xsky130_fd_sc_hd__fill_1_371 VSS VDD VDD sky130_fd_sc_hd__fill_1
* cell instance sky130_fd_sc_hd__fill_1_372 r0 *1 0,0
Xsky130_fd_sc_hd__fill_1_372 VSS VDD VDD sky130_fd_sc_hd__fill_1
* cell instance sky130_fd_sc_hd__fill_1_373 r0 *1 0,0
Xsky130_fd_sc_hd__fill_1_373 VSS VDD VDD sky130_fd_sc_hd__fill_1
* cell instance sky130_fd_sc_hd__fill_1_374 r0 *1 0,0
Xsky130_fd_sc_hd__fill_1_374 VSS VDD VDD sky130_fd_sc_hd__fill_1
* cell instance sky130_fd_sc_hd__fill_1_375 r0 *1 0,0
Xsky130_fd_sc_hd__fill_1_375 VSS VDD VDD sky130_fd_sc_hd__fill_1
* cell instance sky130_fd_sc_hd__fill_1_376 r0 *1 0,0
Xsky130_fd_sc_hd__fill_1_376 VSS VDD VDD sky130_fd_sc_hd__fill_1
* cell instance sky130_fd_sc_hd__fill_1_377 r0 *1 0,0
Xsky130_fd_sc_hd__fill_1_377 VSS VDD VDD sky130_fd_sc_hd__fill_1
* cell instance sky130_fd_sc_hd__fill_1_378 r0 *1 0,0
Xsky130_fd_sc_hd__fill_1_378 VSS VDD VDD sky130_fd_sc_hd__fill_1
* cell instance sky130_fd_sc_hd__fill_1_379 r0 *1 0,0
Xsky130_fd_sc_hd__fill_1_379 VSS VDD VDD sky130_fd_sc_hd__fill_1
* cell instance sky130_fd_sc_hd__fill_1_380 r0 *1 0,0
Xsky130_fd_sc_hd__fill_1_380 VSS VDD VDD sky130_fd_sc_hd__fill_1
* cell instance sky130_fd_sc_hd__fill_1_381 r0 *1 0,0
Xsky130_fd_sc_hd__fill_1_381 VSS VDD VDD sky130_fd_sc_hd__fill_1
* cell instance sky130_fd_sc_hd__fill_1_382 r0 *1 0,0
Xsky130_fd_sc_hd__fill_1_382 VSS VDD VDD sky130_fd_sc_hd__fill_1
* cell instance sky130_fd_sc_hd__fill_1_383 r0 *1 0,0
Xsky130_fd_sc_hd__fill_1_383 VSS VDD VDD sky130_fd_sc_hd__fill_1
* cell instance sky130_fd_sc_hd__fill_1_384 r0 *1 0,0
Xsky130_fd_sc_hd__fill_1_384 VSS VDD VDD sky130_fd_sc_hd__fill_1
* cell instance sky130_fd_sc_hd__fill_1_385 r0 *1 0,0
Xsky130_fd_sc_hd__fill_1_385 VSS VDD VDD sky130_fd_sc_hd__fill_1
* cell instance sky130_fd_sc_hd__fill_1_386 r0 *1 0,0
Xsky130_fd_sc_hd__fill_1_386 VSS VDD VDD sky130_fd_sc_hd__fill_1
* cell instance sky130_fd_sc_hd__fill_1_387 r0 *1 0,0
Xsky130_fd_sc_hd__fill_1_387 VSS VDD VDD sky130_fd_sc_hd__fill_1
* cell instance sky130_fd_sc_hd__fill_1_388 r0 *1 0,0
Xsky130_fd_sc_hd__fill_1_388 VSS VDD VDD sky130_fd_sc_hd__fill_1
* cell instance sky130_fd_sc_hd__fill_1_389 r0 *1 0,0
Xsky130_fd_sc_hd__fill_1_389 VSS VDD VDD sky130_fd_sc_hd__fill_1
* cell instance sky130_fd_sc_hd__fill_1_390 r0 *1 0,0
Xsky130_fd_sc_hd__fill_1_390 VSS VDD VDD sky130_fd_sc_hd__fill_1
* cell instance sky130_fd_sc_hd__fill_1_391 r0 *1 0,0
Xsky130_fd_sc_hd__fill_1_391 VSS VDD VDD sky130_fd_sc_hd__fill_1
* cell instance sky130_fd_sc_hd__fill_1_392 r0 *1 0,0
Xsky130_fd_sc_hd__fill_1_392 VSS VDD VDD sky130_fd_sc_hd__fill_1
* cell instance sky130_fd_sc_hd__fill_1_393 r0 *1 0,0
Xsky130_fd_sc_hd__fill_1_393 VSS VDD VDD sky130_fd_sc_hd__fill_1
* cell instance sky130_fd_sc_hd__fill_1_394 r0 *1 0,0
Xsky130_fd_sc_hd__fill_1_394 VSS VDD VDD sky130_fd_sc_hd__fill_1
* cell instance sky130_fd_sc_hd__fill_1_395 r0 *1 0,0
Xsky130_fd_sc_hd__fill_1_395 VSS VDD VDD sky130_fd_sc_hd__fill_1
* cell instance sky130_fd_sc_hd__fill_1_396 r0 *1 0,0
Xsky130_fd_sc_hd__fill_1_396 VSS VDD VDD sky130_fd_sc_hd__fill_1
* cell instance sky130_fd_sc_hd__fill_1_397 r0 *1 0,0
Xsky130_fd_sc_hd__fill_1_397 VSS VDD VDD sky130_fd_sc_hd__fill_1
* cell instance sky130_fd_sc_hd__fill_1_398 r0 *1 0,0
Xsky130_fd_sc_hd__fill_1_398 VSS VDD VDD sky130_fd_sc_hd__fill_1
* cell instance sky130_fd_sc_hd__fill_1_399 r0 *1 0,0
Xsky130_fd_sc_hd__fill_1_399 VSS VDD VDD sky130_fd_sc_hd__fill_1
* cell instance sky130_fd_sc_hd__fill_1_400 r0 *1 0,0
Xsky130_fd_sc_hd__fill_1_400 VSS VDD VDD sky130_fd_sc_hd__fill_1
* cell instance sky130_fd_sc_hd__fill_1_401 r0 *1 0,0
Xsky130_fd_sc_hd__fill_1_401 VSS VDD VDD sky130_fd_sc_hd__fill_1
* cell instance sky130_fd_sc_hd__fill_1_402 r0 *1 0,0
Xsky130_fd_sc_hd__fill_1_402 VSS VDD VDD sky130_fd_sc_hd__fill_1
* cell instance sky130_fd_sc_hd__fill_1_403 r0 *1 0,0
Xsky130_fd_sc_hd__fill_1_403 VSS VDD VDD sky130_fd_sc_hd__fill_1
* cell instance sky130_fd_sc_hd__fill_1_404 r0 *1 0,0
Xsky130_fd_sc_hd__fill_1_404 VSS VDD VDD sky130_fd_sc_hd__fill_1
* cell instance sky130_fd_sc_hd__fill_1_405 r0 *1 0,0
Xsky130_fd_sc_hd__fill_1_405 VSS VDD VDD sky130_fd_sc_hd__fill_1
* cell instance sky130_fd_sc_hd__fill_1_406 r0 *1 0,0
Xsky130_fd_sc_hd__fill_1_406 VSS VDD VDD sky130_fd_sc_hd__fill_1
* cell instance sky130_fd_sc_hd__fill_1_407 r0 *1 0,0
Xsky130_fd_sc_hd__fill_1_407 VSS VDD VDD sky130_fd_sc_hd__fill_1
* cell instance sky130_fd_sc_hd__fill_1_408 r0 *1 0,0
Xsky130_fd_sc_hd__fill_1_408 VSS VDD VDD sky130_fd_sc_hd__fill_1
* cell instance sky130_fd_sc_hd__fill_1_409 r0 *1 0,0
Xsky130_fd_sc_hd__fill_1_409 VSS VDD VDD sky130_fd_sc_hd__fill_1
* cell instance sky130_fd_sc_hd__fill_1_410 r0 *1 0,0
Xsky130_fd_sc_hd__fill_1_410 VSS VDD VDD sky130_fd_sc_hd__fill_1
* cell instance sky130_fd_sc_hd__fill_1_411 r0 *1 0,0
Xsky130_fd_sc_hd__fill_1_411 VSS VDD VDD sky130_fd_sc_hd__fill_1
* cell instance sky130_fd_sc_hd__fill_1_412 r0 *1 0,0
Xsky130_fd_sc_hd__fill_1_412 VSS VDD VDD sky130_fd_sc_hd__fill_1
* cell instance sky130_fd_sc_hd__fill_1_413 r0 *1 0,0
Xsky130_fd_sc_hd__fill_1_413 VSS VDD VDD sky130_fd_sc_hd__fill_1
* cell instance sky130_fd_sc_hd__fill_1_414 r0 *1 0,0
Xsky130_fd_sc_hd__fill_1_414 VSS VDD VDD sky130_fd_sc_hd__fill_1
* cell instance sky130_fd_sc_hd__fill_1_415 r0 *1 0,0
Xsky130_fd_sc_hd__fill_1_415 VSS VDD VDD sky130_fd_sc_hd__fill_1
* cell instance sky130_fd_sc_hd__fill_1_416 r0 *1 0,0
Xsky130_fd_sc_hd__fill_1_416 VSS VDD VDD sky130_fd_sc_hd__fill_1
* cell instance sky130_fd_sc_hd__fill_1_417 r0 *1 0,0
Xsky130_fd_sc_hd__fill_1_417 VSS VDD VDD sky130_fd_sc_hd__fill_1
* cell instance sky130_fd_sc_hd__fill_1_418 r0 *1 0,0
Xsky130_fd_sc_hd__fill_1_418 VSS VDD VDD sky130_fd_sc_hd__fill_1
* cell instance sky130_fd_sc_hd__fill_1_419 r0 *1 0,0
Xsky130_fd_sc_hd__fill_1_419 VSS VDD VDD sky130_fd_sc_hd__fill_1
* cell instance sky130_fd_sc_hd__fill_1_420 r0 *1 0,0
Xsky130_fd_sc_hd__fill_1_420 VSS VDD VDD sky130_fd_sc_hd__fill_1
* cell instance sky130_fd_sc_hd__fill_1_421 r0 *1 0,0
Xsky130_fd_sc_hd__fill_1_421 VSS VDD VDD sky130_fd_sc_hd__fill_1
* cell instance sky130_fd_sc_hd__fill_1_422 r0 *1 0,0
Xsky130_fd_sc_hd__fill_1_422 VSS VDD VDD sky130_fd_sc_hd__fill_1
* cell instance sky130_fd_sc_hd__fill_1_423 r0 *1 0,0
Xsky130_fd_sc_hd__fill_1_423 VSS VDD VDD sky130_fd_sc_hd__fill_1
* cell instance sky130_fd_sc_hd__fill_1_424 r0 *1 0,0
Xsky130_fd_sc_hd__fill_1_424 VSS VDD VDD sky130_fd_sc_hd__fill_1
* cell instance sky130_fd_sc_hd__fill_1_425 r0 *1 0,0
Xsky130_fd_sc_hd__fill_1_425 VSS VDD VDD sky130_fd_sc_hd__fill_1
* cell instance sky130_fd_sc_hd__fill_1_426 r0 *1 0,0
Xsky130_fd_sc_hd__fill_1_426 VSS VDD VDD sky130_fd_sc_hd__fill_1
* cell instance sky130_fd_sc_hd__fill_1_427 r0 *1 0,0
Xsky130_fd_sc_hd__fill_1_427 VSS VDD VDD sky130_fd_sc_hd__fill_1
* cell instance sky130_fd_sc_hd__fill_1_428 r0 *1 0,0
Xsky130_fd_sc_hd__fill_1_428 VSS VDD VDD sky130_fd_sc_hd__fill_1
* cell instance sky130_fd_sc_hd__fill_1_429 r0 *1 0,0
Xsky130_fd_sc_hd__fill_1_429 VSS VDD VDD sky130_fd_sc_hd__fill_1
* cell instance sky130_fd_sc_hd__fill_1_430 r0 *1 0,0
Xsky130_fd_sc_hd__fill_1_430 VSS VDD VDD sky130_fd_sc_hd__fill_1
* cell instance sky130_fd_sc_hd__fill_1_431 r0 *1 0,0
Xsky130_fd_sc_hd__fill_1_431 VSS VDD VDD sky130_fd_sc_hd__fill_1
* cell instance sky130_fd_sc_hd__fill_1_432 r0 *1 0,0
Xsky130_fd_sc_hd__fill_1_432 VSS VDD VDD sky130_fd_sc_hd__fill_1
* cell instance sky130_fd_sc_hd__fill_1_433 r0 *1 0,0
Xsky130_fd_sc_hd__fill_1_433 VSS VDD VDD sky130_fd_sc_hd__fill_1
* cell instance sky130_fd_sc_hd__fill_1_434 r0 *1 0,0
Xsky130_fd_sc_hd__fill_1_434 VSS VDD VDD sky130_fd_sc_hd__fill_1
* cell instance sky130_fd_sc_hd__fill_1_435 r0 *1 0,0
Xsky130_fd_sc_hd__fill_1_435 VSS VDD VDD sky130_fd_sc_hd__fill_1
* cell instance sky130_fd_sc_hd__fill_1_436 r0 *1 0,0
Xsky130_fd_sc_hd__fill_1_436 VSS VDD VDD sky130_fd_sc_hd__fill_1
* cell instance sky130_fd_sc_hd__fill_1_437 r0 *1 0,0
Xsky130_fd_sc_hd__fill_1_437 VSS VDD VDD sky130_fd_sc_hd__fill_1
* cell instance sky130_fd_sc_hd__fill_1_438 r0 *1 0,0
Xsky130_fd_sc_hd__fill_1_438 VSS VDD VDD sky130_fd_sc_hd__fill_1
* cell instance sky130_fd_sc_hd__fill_1_439 r0 *1 0,0
Xsky130_fd_sc_hd__fill_1_439 VSS VDD VDD sky130_fd_sc_hd__fill_1
* cell instance sky130_fd_sc_hd__fill_1_440 r0 *1 0,0
Xsky130_fd_sc_hd__fill_1_440 VSS VDD VDD sky130_fd_sc_hd__fill_1
* cell instance sky130_fd_sc_hd__fill_1_441 r0 *1 0,0
Xsky130_fd_sc_hd__fill_1_441 VSS VDD VDD sky130_fd_sc_hd__fill_1
* cell instance sky130_fd_sc_hd__fill_1_442 r0 *1 0,0
Xsky130_fd_sc_hd__fill_1_442 VSS VDD VDD sky130_fd_sc_hd__fill_1
* cell instance sky130_fd_sc_hd__fill_1_443 r0 *1 0,0
Xsky130_fd_sc_hd__fill_1_443 VSS VDD VDD sky130_fd_sc_hd__fill_1
* cell instance sky130_fd_sc_hd__fill_1_444 r0 *1 0,0
Xsky130_fd_sc_hd__fill_1_444 VSS VDD VDD sky130_fd_sc_hd__fill_1
* cell instance sky130_fd_sc_hd__fill_1_445 r0 *1 0,0
Xsky130_fd_sc_hd__fill_1_445 VSS VDD VDD sky130_fd_sc_hd__fill_1
* cell instance sky130_fd_sc_hd__fill_1_446 r0 *1 0,0
Xsky130_fd_sc_hd__fill_1_446 VSS VDD VDD sky130_fd_sc_hd__fill_1
* cell instance sky130_fd_sc_hd__fill_1_447 r0 *1 0,0
Xsky130_fd_sc_hd__fill_1_447 VSS VDD VDD sky130_fd_sc_hd__fill_1
* cell instance sky130_fd_sc_hd__fill_1_448 r0 *1 0,0
Xsky130_fd_sc_hd__fill_1_448 VSS VDD VDD sky130_fd_sc_hd__fill_1
* cell instance sky130_fd_sc_hd__fill_1_449 r0 *1 0,0
Xsky130_fd_sc_hd__fill_1_449 VSS VDD VDD sky130_fd_sc_hd__fill_1
* cell instance sky130_fd_sc_hd__fill_1_450 r0 *1 0,0
Xsky130_fd_sc_hd__fill_1_450 VSS VDD VDD sky130_fd_sc_hd__fill_1
* cell instance sky130_fd_sc_hd__fill_1_451 r0 *1 0,0
Xsky130_fd_sc_hd__fill_1_451 VSS VDD VDD sky130_fd_sc_hd__fill_1
* cell instance sky130_fd_sc_hd__fill_1_452 r0 *1 0,0
Xsky130_fd_sc_hd__fill_1_452 VSS VDD VDD sky130_fd_sc_hd__fill_1
* cell instance sky130_fd_sc_hd__fill_1_453 r0 *1 0,0
Xsky130_fd_sc_hd__fill_1_453 VSS VDD VDD sky130_fd_sc_hd__fill_1
* cell instance sky130_fd_sc_hd__fill_1_454 r0 *1 0,0
Xsky130_fd_sc_hd__fill_1_454 VSS VDD VDD sky130_fd_sc_hd__fill_1
* cell instance sky130_fd_sc_hd__fill_1_455 r0 *1 0,0
Xsky130_fd_sc_hd__fill_1_455 VSS VDD VDD sky130_fd_sc_hd__fill_1
* cell instance sky130_fd_sc_hd__fill_1_456 r0 *1 0,0
Xsky130_fd_sc_hd__fill_1_456 VSS VDD VDD sky130_fd_sc_hd__fill_1
* cell instance sky130_fd_sc_hd__fill_1_457 r0 *1 0,0
Xsky130_fd_sc_hd__fill_1_457 VSS VDD VDD sky130_fd_sc_hd__fill_1
* cell instance sky130_fd_sc_hd__fill_1_458 r0 *1 0,0
Xsky130_fd_sc_hd__fill_1_458 VSS VDD VDD sky130_fd_sc_hd__fill_1
* cell instance sky130_fd_sc_hd__fill_1_459 r0 *1 0,0
Xsky130_fd_sc_hd__fill_1_459 VSS VDD VDD sky130_fd_sc_hd__fill_1
* cell instance sky130_fd_sc_hd__fill_1_460 r0 *1 0,0
Xsky130_fd_sc_hd__fill_1_460 VSS VDD VDD sky130_fd_sc_hd__fill_1
* cell instance sky130_fd_sc_hd__fill_1_461 r0 *1 0,0
Xsky130_fd_sc_hd__fill_1_461 VSS VDD VDD sky130_fd_sc_hd__fill_1
* cell instance sky130_fd_sc_hd__fill_1_462 r0 *1 0,0
Xsky130_fd_sc_hd__fill_1_462 VSS VDD VDD sky130_fd_sc_hd__fill_1
* cell instance sky130_fd_sc_hd__fill_1_463 r0 *1 0,0
Xsky130_fd_sc_hd__fill_1_463 VSS VDD VDD sky130_fd_sc_hd__fill_1
* cell instance sky130_fd_sc_hd__fill_1_464 r0 *1 0,0
Xsky130_fd_sc_hd__fill_1_464 VSS VDD VDD sky130_fd_sc_hd__fill_1
* cell instance sky130_fd_sc_hd__fill_1_465 r0 *1 0,0
Xsky130_fd_sc_hd__fill_1_465 VSS VDD VDD sky130_fd_sc_hd__fill_1
* cell instance sky130_fd_sc_hd__fill_1_466 r0 *1 0,0
Xsky130_fd_sc_hd__fill_1_466 VSS VDD VDD sky130_fd_sc_hd__fill_1
* cell instance sky130_fd_sc_hd__fill_1_467 r0 *1 0,0
Xsky130_fd_sc_hd__fill_1_467 VSS VDD VDD sky130_fd_sc_hd__fill_1
* cell instance sky130_fd_sc_hd__fill_1_468 r0 *1 0,0
Xsky130_fd_sc_hd__fill_1_468 VSS VDD VDD sky130_fd_sc_hd__fill_1
* cell instance sky130_fd_sc_hd__fill_1_469 r0 *1 0,0
Xsky130_fd_sc_hd__fill_1_469 VSS VDD VDD sky130_fd_sc_hd__fill_1
* cell instance sky130_fd_sc_hd__fill_1_470 r0 *1 0,0
Xsky130_fd_sc_hd__fill_1_470 VSS VDD VDD sky130_fd_sc_hd__fill_1
* cell instance sky130_fd_sc_hd__fill_1_471 r0 *1 0,0
Xsky130_fd_sc_hd__fill_1_471 VSS VDD VDD sky130_fd_sc_hd__fill_1
* cell instance sky130_fd_sc_hd__fill_1_472 r0 *1 0,0
Xsky130_fd_sc_hd__fill_1_472 VSS VDD VDD sky130_fd_sc_hd__fill_1
* cell instance sky130_fd_sc_hd__fill_1_473 r0 *1 0,0
Xsky130_fd_sc_hd__fill_1_473 VSS VDD VDD sky130_fd_sc_hd__fill_1
* cell instance sky130_fd_sc_hd__fill_1_474 r0 *1 0,0
Xsky130_fd_sc_hd__fill_1_474 VSS VDD VDD sky130_fd_sc_hd__fill_1
* cell instance sky130_fd_sc_hd__fill_1_475 r0 *1 0,0
Xsky130_fd_sc_hd__fill_1_475 VSS VDD VDD sky130_fd_sc_hd__fill_1
* cell instance sky130_fd_sc_hd__fill_1_476 r0 *1 0,0
Xsky130_fd_sc_hd__fill_1_476 VSS VDD VDD sky130_fd_sc_hd__fill_1
* cell instance sky130_fd_sc_hd__fill_1_477 r0 *1 0,0
Xsky130_fd_sc_hd__fill_1_477 VSS VDD VDD sky130_fd_sc_hd__fill_1
* cell instance sky130_fd_sc_hd__fill_1_478 r0 *1 0,0
Xsky130_fd_sc_hd__fill_1_478 VSS VDD VDD sky130_fd_sc_hd__fill_1
* cell instance sky130_fd_sc_hd__fill_1_479 r0 *1 0,0
Xsky130_fd_sc_hd__fill_1_479 VSS VDD VDD sky130_fd_sc_hd__fill_1
* cell instance sky130_fd_sc_hd__fill_1_480 r0 *1 0,0
Xsky130_fd_sc_hd__fill_1_480 VSS VDD VDD sky130_fd_sc_hd__fill_1
* cell instance sky130_fd_sc_hd__fill_1_481 r0 *1 0,0
Xsky130_fd_sc_hd__fill_1_481 VSS VDD VDD sky130_fd_sc_hd__fill_1
* cell instance sky130_fd_sc_hd__fill_1_482 r0 *1 0,0
Xsky130_fd_sc_hd__fill_1_482 VSS VDD VDD sky130_fd_sc_hd__fill_1
* cell instance sky130_fd_sc_hd__fill_1_483 r0 *1 0,0
Xsky130_fd_sc_hd__fill_1_483 VSS VDD VDD sky130_fd_sc_hd__fill_1
* cell instance sky130_fd_sc_hd__fill_1_484 r0 *1 0,0
Xsky130_fd_sc_hd__fill_1_484 VSS VDD VDD sky130_fd_sc_hd__fill_1
* cell instance sky130_fd_sc_hd__fill_1_485 r0 *1 0,0
Xsky130_fd_sc_hd__fill_1_485 VSS VDD VDD sky130_fd_sc_hd__fill_1
* cell instance sky130_fd_sc_hd__fill_1_486 r0 *1 0,0
Xsky130_fd_sc_hd__fill_1_486 VSS VDD VDD sky130_fd_sc_hd__fill_1
* cell instance sky130_fd_sc_hd__fill_1_487 r0 *1 0,0
Xsky130_fd_sc_hd__fill_1_487 VSS VDD VDD sky130_fd_sc_hd__fill_1
* cell instance sky130_fd_sc_hd__fill_1_488 r0 *1 0,0
Xsky130_fd_sc_hd__fill_1_488 VSS VDD VDD sky130_fd_sc_hd__fill_1
* cell instance sky130_fd_sc_hd__fill_2_0 r0 *1 0,0
Xsky130_fd_sc_hd__fill_2_0 VSS VDD VDD sky130_fd_sc_hd__fill_2
* cell instance sky130_fd_sc_hd__fill_2_1 r0 *1 0,0
Xsky130_fd_sc_hd__fill_2_1 VSS VDD VDD sky130_fd_sc_hd__fill_2
* cell instance sky130_fd_sc_hd__fill_2_2 r0 *1 0,0
Xsky130_fd_sc_hd__fill_2_2 VSS VDD VDD sky130_fd_sc_hd__fill_2
* cell instance sky130_fd_sc_hd__fill_2_3 r0 *1 0,0
Xsky130_fd_sc_hd__fill_2_3 VSS VDD VDD sky130_fd_sc_hd__fill_2
* cell instance sky130_fd_sc_hd__fill_2_4 r0 *1 0,0
Xsky130_fd_sc_hd__fill_2_4 VSS VDD VDD sky130_fd_sc_hd__fill_2
* cell instance sky130_fd_sc_hd__fill_2_5 r0 *1 0,0
Xsky130_fd_sc_hd__fill_2_5 VSS VDD VDD sky130_fd_sc_hd__fill_2
* cell instance sky130_fd_sc_hd__fill_2_6 r0 *1 0,0
Xsky130_fd_sc_hd__fill_2_6 VSS VDD VDD sky130_fd_sc_hd__fill_2
* cell instance sky130_fd_sc_hd__fill_2_7 r0 *1 0,0
Xsky130_fd_sc_hd__fill_2_7 VSS VDD VDD sky130_fd_sc_hd__fill_2
* cell instance sky130_fd_sc_hd__fill_2_8 r0 *1 0,0
Xsky130_fd_sc_hd__fill_2_8 VSS VDD VDD sky130_fd_sc_hd__fill_2
* cell instance sky130_fd_sc_hd__fill_2_9 r0 *1 0,0
Xsky130_fd_sc_hd__fill_2_9 VSS VDD VDD sky130_fd_sc_hd__fill_2
* cell instance sky130_fd_sc_hd__fill_2_10 r0 *1 0,0
Xsky130_fd_sc_hd__fill_2_10 VSS VDD VDD sky130_fd_sc_hd__fill_2
* cell instance sky130_fd_sc_hd__fill_2_11 r0 *1 0,0
Xsky130_fd_sc_hd__fill_2_11 VSS VDD VDD sky130_fd_sc_hd__fill_2
* cell instance sky130_fd_sc_hd__fill_2_12 r0 *1 0,0
Xsky130_fd_sc_hd__fill_2_12 VSS VDD VDD sky130_fd_sc_hd__fill_2
* cell instance sky130_fd_sc_hd__fill_2_13 r0 *1 0,0
Xsky130_fd_sc_hd__fill_2_13 VSS VDD VDD sky130_fd_sc_hd__fill_2
* cell instance sky130_fd_sc_hd__fill_2_14 r0 *1 0,0
Xsky130_fd_sc_hd__fill_2_14 VSS VDD VDD sky130_fd_sc_hd__fill_2
* cell instance sky130_fd_sc_hd__fill_2_15 r0 *1 0,0
Xsky130_fd_sc_hd__fill_2_15 VSS VDD VDD sky130_fd_sc_hd__fill_2
* cell instance sky130_fd_sc_hd__fill_2_16 r0 *1 0,0
Xsky130_fd_sc_hd__fill_2_16 VSS VDD VDD sky130_fd_sc_hd__fill_2
* cell instance sky130_fd_sc_hd__fill_2_17 r0 *1 0,0
Xsky130_fd_sc_hd__fill_2_17 VSS VDD VDD sky130_fd_sc_hd__fill_2
* cell instance sky130_fd_sc_hd__fill_2_18 r0 *1 0,0
Xsky130_fd_sc_hd__fill_2_18 VSS VDD VDD sky130_fd_sc_hd__fill_2
* cell instance sky130_fd_sc_hd__fill_2_19 r0 *1 0,0
Xsky130_fd_sc_hd__fill_2_19 VSS VDD VDD sky130_fd_sc_hd__fill_2
* cell instance sky130_fd_sc_hd__fill_2_20 r0 *1 0,0
Xsky130_fd_sc_hd__fill_2_20 VSS VDD VDD sky130_fd_sc_hd__fill_2
* cell instance sky130_fd_sc_hd__fill_2_21 r0 *1 0,0
Xsky130_fd_sc_hd__fill_2_21 VSS VDD VDD sky130_fd_sc_hd__fill_2
* cell instance sky130_fd_sc_hd__fill_2_22 r0 *1 0,0
Xsky130_fd_sc_hd__fill_2_22 VSS VDD VDD sky130_fd_sc_hd__fill_2
* cell instance sky130_fd_sc_hd__fill_2_23 r0 *1 0,0
Xsky130_fd_sc_hd__fill_2_23 VSS VDD VDD sky130_fd_sc_hd__fill_2
* cell instance sky130_fd_sc_hd__fill_2_24 r0 *1 0,0
Xsky130_fd_sc_hd__fill_2_24 VSS VDD VDD sky130_fd_sc_hd__fill_2
* cell instance sky130_fd_sc_hd__fill_2_25 r0 *1 0,0
Xsky130_fd_sc_hd__fill_2_25 VSS VDD VDD sky130_fd_sc_hd__fill_2
* cell instance sky130_fd_sc_hd__fill_2_26 r0 *1 0,0
Xsky130_fd_sc_hd__fill_2_26 VSS VDD VDD sky130_fd_sc_hd__fill_2
* cell instance sky130_fd_sc_hd__fill_2_27 r0 *1 0,0
Xsky130_fd_sc_hd__fill_2_27 VSS VDD VDD sky130_fd_sc_hd__fill_2
* cell instance sky130_fd_sc_hd__fill_2_28 r0 *1 0,0
Xsky130_fd_sc_hd__fill_2_28 VSS VDD VDD sky130_fd_sc_hd__fill_2
* cell instance sky130_fd_sc_hd__fill_2_29 r0 *1 0,0
Xsky130_fd_sc_hd__fill_2_29 VSS VDD VDD sky130_fd_sc_hd__fill_2
* cell instance sky130_fd_sc_hd__fill_2_30 r0 *1 0,0
Xsky130_fd_sc_hd__fill_2_30 VSS VDD VDD sky130_fd_sc_hd__fill_2
* cell instance sky130_fd_sc_hd__fill_2_31 r0 *1 0,0
Xsky130_fd_sc_hd__fill_2_31 VSS VDD VDD sky130_fd_sc_hd__fill_2
* cell instance sky130_fd_sc_hd__fill_2_32 r0 *1 0,0
Xsky130_fd_sc_hd__fill_2_32 VSS VDD VDD sky130_fd_sc_hd__fill_2
* cell instance sky130_fd_sc_hd__fill_2_33 r0 *1 0,0
Xsky130_fd_sc_hd__fill_2_33 VSS VDD VDD sky130_fd_sc_hd__fill_2
* cell instance sky130_fd_sc_hd__fill_2_34 r0 *1 0,0
Xsky130_fd_sc_hd__fill_2_34 VSS VDD VDD sky130_fd_sc_hd__fill_2
* cell instance sky130_fd_sc_hd__fill_2_35 r0 *1 0,0
Xsky130_fd_sc_hd__fill_2_35 VSS VDD VDD sky130_fd_sc_hd__fill_2
* cell instance sky130_fd_sc_hd__fill_2_36 r0 *1 0,0
Xsky130_fd_sc_hd__fill_2_36 VSS VDD VDD sky130_fd_sc_hd__fill_2
* cell instance sky130_fd_sc_hd__fill_2_37 r0 *1 0,0
Xsky130_fd_sc_hd__fill_2_37 VSS VDD VDD sky130_fd_sc_hd__fill_2
* cell instance sky130_fd_sc_hd__fill_2_38 r0 *1 0,0
Xsky130_fd_sc_hd__fill_2_38 VSS VDD VDD sky130_fd_sc_hd__fill_2
* cell instance sky130_fd_sc_hd__fill_2_39 r0 *1 0,0
Xsky130_fd_sc_hd__fill_2_39 VSS VDD VDD sky130_fd_sc_hd__fill_2
* cell instance sky130_fd_sc_hd__fill_2_40 r0 *1 0,0
Xsky130_fd_sc_hd__fill_2_40 VSS VDD VDD sky130_fd_sc_hd__fill_2
* cell instance sky130_fd_sc_hd__fill_2_41 r0 *1 0,0
Xsky130_fd_sc_hd__fill_2_41 VSS VDD VDD sky130_fd_sc_hd__fill_2
* cell instance sky130_fd_sc_hd__fill_2_42 r0 *1 0,0
Xsky130_fd_sc_hd__fill_2_42 VSS VDD VDD sky130_fd_sc_hd__fill_2
* cell instance sky130_fd_sc_hd__fill_2_43 r0 *1 0,0
Xsky130_fd_sc_hd__fill_2_43 VSS VDD VDD sky130_fd_sc_hd__fill_2
* cell instance sky130_fd_sc_hd__fill_2_44 r0 *1 0,0
Xsky130_fd_sc_hd__fill_2_44 VSS VDD VDD sky130_fd_sc_hd__fill_2
* cell instance sky130_fd_sc_hd__fill_2_45 r0 *1 0,0
Xsky130_fd_sc_hd__fill_2_45 VSS VDD VDD sky130_fd_sc_hd__fill_2
* cell instance sky130_fd_sc_hd__fill_2_46 r0 *1 0,0
Xsky130_fd_sc_hd__fill_2_46 VSS VDD VDD sky130_fd_sc_hd__fill_2
* cell instance sky130_fd_sc_hd__fill_2_47 r0 *1 0,0
Xsky130_fd_sc_hd__fill_2_47 VSS VDD VDD sky130_fd_sc_hd__fill_2
* cell instance sky130_fd_sc_hd__fill_2_48 r0 *1 0,0
Xsky130_fd_sc_hd__fill_2_48 VSS VDD VDD sky130_fd_sc_hd__fill_2
* cell instance sky130_fd_sc_hd__fill_2_49 r0 *1 0,0
Xsky130_fd_sc_hd__fill_2_49 VSS VDD VDD sky130_fd_sc_hd__fill_2
* cell instance sky130_fd_sc_hd__fill_2_50 r0 *1 0,0
Xsky130_fd_sc_hd__fill_2_50 VSS VDD VDD sky130_fd_sc_hd__fill_2
* cell instance sky130_fd_sc_hd__fill_2_51 r0 *1 0,0
Xsky130_fd_sc_hd__fill_2_51 VSS VDD VDD sky130_fd_sc_hd__fill_2
* cell instance sky130_fd_sc_hd__fill_2_52 r0 *1 0,0
Xsky130_fd_sc_hd__fill_2_52 VSS VDD VDD sky130_fd_sc_hd__fill_2
* cell instance sky130_fd_sc_hd__fill_2_53 r0 *1 0,0
Xsky130_fd_sc_hd__fill_2_53 VSS VDD VDD sky130_fd_sc_hd__fill_2
* cell instance sky130_fd_sc_hd__fill_2_54 r0 *1 0,0
Xsky130_fd_sc_hd__fill_2_54 VSS VDD VDD sky130_fd_sc_hd__fill_2
* cell instance sky130_fd_sc_hd__fill_2_55 r0 *1 0,0
Xsky130_fd_sc_hd__fill_2_55 VSS VDD VDD sky130_fd_sc_hd__fill_2
* cell instance sky130_fd_sc_hd__fill_2_56 r0 *1 0,0
Xsky130_fd_sc_hd__fill_2_56 VSS VDD VDD sky130_fd_sc_hd__fill_2
* cell instance sky130_fd_sc_hd__fill_2_57 r0 *1 0,0
Xsky130_fd_sc_hd__fill_2_57 VSS VDD VDD sky130_fd_sc_hd__fill_2
* cell instance sky130_fd_sc_hd__fill_2_58 r0 *1 0,0
Xsky130_fd_sc_hd__fill_2_58 VSS VDD VDD sky130_fd_sc_hd__fill_2
* cell instance sky130_fd_sc_hd__fill_2_59 r0 *1 0,0
Xsky130_fd_sc_hd__fill_2_59 VSS VDD VDD sky130_fd_sc_hd__fill_2
* cell instance sky130_fd_sc_hd__fill_2_60 r0 *1 0,0
Xsky130_fd_sc_hd__fill_2_60 VSS VDD VDD sky130_fd_sc_hd__fill_2
* cell instance sky130_fd_sc_hd__fill_2_61 r0 *1 0,0
Xsky130_fd_sc_hd__fill_2_61 VSS VDD VDD sky130_fd_sc_hd__fill_2
* cell instance sky130_fd_sc_hd__fill_2_62 r0 *1 0,0
Xsky130_fd_sc_hd__fill_2_62 VSS VDD VDD sky130_fd_sc_hd__fill_2
* cell instance sky130_fd_sc_hd__fill_2_63 r0 *1 0,0
Xsky130_fd_sc_hd__fill_2_63 VSS VDD VDD sky130_fd_sc_hd__fill_2
* cell instance sky130_fd_sc_hd__fill_2_64 r0 *1 0,0
Xsky130_fd_sc_hd__fill_2_64 VSS VDD VDD sky130_fd_sc_hd__fill_2
* cell instance sky130_fd_sc_hd__fill_2_65 r0 *1 0,0
Xsky130_fd_sc_hd__fill_2_65 VSS VDD VDD sky130_fd_sc_hd__fill_2
* cell instance sky130_fd_sc_hd__fill_2_66 r0 *1 0,0
Xsky130_fd_sc_hd__fill_2_66 VSS VDD VDD sky130_fd_sc_hd__fill_2
* cell instance sky130_fd_sc_hd__fill_2_67 r0 *1 0,0
Xsky130_fd_sc_hd__fill_2_67 VSS VDD VDD sky130_fd_sc_hd__fill_2
* cell instance sky130_fd_sc_hd__fill_2_68 r0 *1 0,0
Xsky130_fd_sc_hd__fill_2_68 VSS VDD VDD sky130_fd_sc_hd__fill_2
* cell instance sky130_fd_sc_hd__fill_2_69 r0 *1 0,0
Xsky130_fd_sc_hd__fill_2_69 VSS VDD VDD sky130_fd_sc_hd__fill_2
* cell instance sky130_fd_sc_hd__fill_2_70 r0 *1 0,0
Xsky130_fd_sc_hd__fill_2_70 VSS VDD VDD sky130_fd_sc_hd__fill_2
* cell instance sky130_fd_sc_hd__fill_2_71 r0 *1 0,0
Xsky130_fd_sc_hd__fill_2_71 VSS VDD VDD sky130_fd_sc_hd__fill_2
* cell instance sky130_fd_sc_hd__fill_2_72 r0 *1 0,0
Xsky130_fd_sc_hd__fill_2_72 VSS VDD VDD sky130_fd_sc_hd__fill_2
* cell instance sky130_fd_sc_hd__fill_2_73 r0 *1 0,0
Xsky130_fd_sc_hd__fill_2_73 VSS VDD VDD sky130_fd_sc_hd__fill_2
* cell instance sky130_fd_sc_hd__fill_2_74 r0 *1 0,0
Xsky130_fd_sc_hd__fill_2_74 VSS VDD VDD sky130_fd_sc_hd__fill_2
* cell instance sky130_fd_sc_hd__fill_2_75 r0 *1 0,0
Xsky130_fd_sc_hd__fill_2_75 VSS VDD VDD sky130_fd_sc_hd__fill_2
* cell instance sky130_fd_sc_hd__fill_2_76 r0 *1 0,0
Xsky130_fd_sc_hd__fill_2_76 VSS VDD VDD sky130_fd_sc_hd__fill_2
* cell instance sky130_fd_sc_hd__fill_2_77 r0 *1 0,0
Xsky130_fd_sc_hd__fill_2_77 VSS VDD VDD sky130_fd_sc_hd__fill_2
* cell instance sky130_fd_sc_hd__fill_2_78 r0 *1 0,0
Xsky130_fd_sc_hd__fill_2_78 VSS VDD VDD sky130_fd_sc_hd__fill_2
* cell instance sky130_fd_sc_hd__fill_2_79 r0 *1 0,0
Xsky130_fd_sc_hd__fill_2_79 VSS VDD VDD sky130_fd_sc_hd__fill_2
* cell instance sky130_fd_sc_hd__fill_2_80 r0 *1 0,0
Xsky130_fd_sc_hd__fill_2_80 VSS VDD VDD sky130_fd_sc_hd__fill_2
* cell instance sky130_fd_sc_hd__fill_2_81 r0 *1 0,0
Xsky130_fd_sc_hd__fill_2_81 VSS VDD VDD sky130_fd_sc_hd__fill_2
* cell instance sky130_fd_sc_hd__fill_2_82 r0 *1 0,0
Xsky130_fd_sc_hd__fill_2_82 VSS VDD VDD sky130_fd_sc_hd__fill_2
* cell instance sky130_fd_sc_hd__fill_2_83 r0 *1 0,0
Xsky130_fd_sc_hd__fill_2_83 VSS VDD VDD sky130_fd_sc_hd__fill_2
* cell instance sky130_fd_sc_hd__fill_2_84 r0 *1 0,0
Xsky130_fd_sc_hd__fill_2_84 VSS VDD VDD sky130_fd_sc_hd__fill_2
* cell instance sky130_fd_sc_hd__fill_2_85 r0 *1 0,0
Xsky130_fd_sc_hd__fill_2_85 VSS VDD VDD sky130_fd_sc_hd__fill_2
* cell instance sky130_fd_sc_hd__fill_2_86 r0 *1 0,0
Xsky130_fd_sc_hd__fill_2_86 VSS VDD VDD sky130_fd_sc_hd__fill_2
* cell instance sky130_fd_sc_hd__fill_2_87 r0 *1 0,0
Xsky130_fd_sc_hd__fill_2_87 VSS VDD VDD sky130_fd_sc_hd__fill_2
* cell instance sky130_fd_sc_hd__fill_2_88 r0 *1 0,0
Xsky130_fd_sc_hd__fill_2_88 VSS VDD VDD sky130_fd_sc_hd__fill_2
* cell instance sky130_fd_sc_hd__fill_2_89 r0 *1 0,0
Xsky130_fd_sc_hd__fill_2_89 VSS VDD VDD sky130_fd_sc_hd__fill_2
* cell instance sky130_fd_sc_hd__fill_2_90 r0 *1 0,0
Xsky130_fd_sc_hd__fill_2_90 VSS VDD VDD sky130_fd_sc_hd__fill_2
* cell instance sky130_fd_sc_hd__fill_2_91 r0 *1 0,0
Xsky130_fd_sc_hd__fill_2_91 VSS VDD VDD sky130_fd_sc_hd__fill_2
* cell instance sky130_fd_sc_hd__fill_2_92 r0 *1 0,0
Xsky130_fd_sc_hd__fill_2_92 VSS VDD VDD sky130_fd_sc_hd__fill_2
* cell instance sky130_fd_sc_hd__fill_2_93 r0 *1 0,0
Xsky130_fd_sc_hd__fill_2_93 VSS VDD VDD sky130_fd_sc_hd__fill_2
* cell instance sky130_fd_sc_hd__fill_2_94 r0 *1 0,0
Xsky130_fd_sc_hd__fill_2_94 VSS VDD VDD sky130_fd_sc_hd__fill_2
* cell instance sky130_fd_sc_hd__fill_2_95 r0 *1 0,0
Xsky130_fd_sc_hd__fill_2_95 VSS VDD VDD sky130_fd_sc_hd__fill_2
* cell instance sky130_fd_sc_hd__fill_2_96 r0 *1 0,0
Xsky130_fd_sc_hd__fill_2_96 VSS VDD VDD sky130_fd_sc_hd__fill_2
* cell instance sky130_fd_sc_hd__fill_2_97 r0 *1 0,0
Xsky130_fd_sc_hd__fill_2_97 VSS VDD VDD sky130_fd_sc_hd__fill_2
* cell instance sky130_fd_sc_hd__fill_2_98 r0 *1 0,0
Xsky130_fd_sc_hd__fill_2_98 VSS VDD VDD sky130_fd_sc_hd__fill_2
* cell instance sky130_fd_sc_hd__fill_2_99 r0 *1 0,0
Xsky130_fd_sc_hd__fill_2_99 VSS VDD VDD sky130_fd_sc_hd__fill_2
* cell instance sky130_fd_sc_hd__fill_2_100 r0 *1 0,0
Xsky130_fd_sc_hd__fill_2_100 VSS VDD VDD sky130_fd_sc_hd__fill_2
* cell instance sky130_fd_sc_hd__fill_2_101 r0 *1 0,0
Xsky130_fd_sc_hd__fill_2_101 VSS VDD VDD sky130_fd_sc_hd__fill_2
* cell instance sky130_fd_sc_hd__fill_2_102 r0 *1 0,0
Xsky130_fd_sc_hd__fill_2_102 VSS VDD VDD sky130_fd_sc_hd__fill_2
* cell instance sky130_fd_sc_hd__fill_2_103 r0 *1 0,0
Xsky130_fd_sc_hd__fill_2_103 VSS VDD VDD sky130_fd_sc_hd__fill_2
* cell instance sky130_fd_sc_hd__fill_2_104 r0 *1 0,0
Xsky130_fd_sc_hd__fill_2_104 VSS VDD VDD sky130_fd_sc_hd__fill_2
* cell instance sky130_fd_sc_hd__fill_2_105 r0 *1 0,0
Xsky130_fd_sc_hd__fill_2_105 VSS VDD VDD sky130_fd_sc_hd__fill_2
* cell instance sky130_fd_sc_hd__fill_2_106 r0 *1 0,0
Xsky130_fd_sc_hd__fill_2_106 VSS VDD VDD sky130_fd_sc_hd__fill_2
* cell instance sky130_fd_sc_hd__fill_2_107 r0 *1 0,0
Xsky130_fd_sc_hd__fill_2_107 VSS VDD VDD sky130_fd_sc_hd__fill_2
* cell instance sky130_fd_sc_hd__fill_2_108 r0 *1 0,0
Xsky130_fd_sc_hd__fill_2_108 VSS VDD VDD sky130_fd_sc_hd__fill_2
* cell instance sky130_fd_sc_hd__fill_2_109 r0 *1 0,0
Xsky130_fd_sc_hd__fill_2_109 VSS VDD VDD sky130_fd_sc_hd__fill_2
* cell instance sky130_fd_sc_hd__fill_2_110 r0 *1 0,0
Xsky130_fd_sc_hd__fill_2_110 VSS VDD VDD sky130_fd_sc_hd__fill_2
* cell instance sky130_fd_sc_hd__fill_2_111 r0 *1 0,0
Xsky130_fd_sc_hd__fill_2_111 VSS VDD VDD sky130_fd_sc_hd__fill_2
* cell instance sky130_fd_sc_hd__fill_2_112 r0 *1 0,0
Xsky130_fd_sc_hd__fill_2_112 VSS VDD VDD sky130_fd_sc_hd__fill_2
* cell instance sky130_fd_sc_hd__fill_2_113 r0 *1 0,0
Xsky130_fd_sc_hd__fill_2_113 VSS VDD VDD sky130_fd_sc_hd__fill_2
* cell instance sky130_fd_sc_hd__fill_2_114 r0 *1 0,0
Xsky130_fd_sc_hd__fill_2_114 VSS VDD VDD sky130_fd_sc_hd__fill_2
* cell instance sky130_fd_sc_hd__fill_2_115 r0 *1 0,0
Xsky130_fd_sc_hd__fill_2_115 VSS VDD VDD sky130_fd_sc_hd__fill_2
* cell instance sky130_fd_sc_hd__fill_2_116 r0 *1 0,0
Xsky130_fd_sc_hd__fill_2_116 VSS VDD VDD sky130_fd_sc_hd__fill_2
* cell instance sky130_fd_sc_hd__fill_2_117 r0 *1 0,0
Xsky130_fd_sc_hd__fill_2_117 VSS VDD VDD sky130_fd_sc_hd__fill_2
* cell instance sky130_fd_sc_hd__fill_2_118 r0 *1 0,0
Xsky130_fd_sc_hd__fill_2_118 VSS VDD VDD sky130_fd_sc_hd__fill_2
* cell instance sky130_fd_sc_hd__fill_2_119 r0 *1 0,0
Xsky130_fd_sc_hd__fill_2_119 VSS VDD VDD sky130_fd_sc_hd__fill_2
* cell instance sky130_fd_sc_hd__fill_2_120 r0 *1 0,0
Xsky130_fd_sc_hd__fill_2_120 VSS VDD VDD sky130_fd_sc_hd__fill_2
* cell instance sky130_fd_sc_hd__fill_2_121 r0 *1 0,0
Xsky130_fd_sc_hd__fill_2_121 VSS VDD VDD sky130_fd_sc_hd__fill_2
* cell instance sky130_fd_sc_hd__fill_2_122 r0 *1 0,0
Xsky130_fd_sc_hd__fill_2_122 VSS VDD VDD sky130_fd_sc_hd__fill_2
* cell instance sky130_fd_sc_hd__fill_2_123 r0 *1 0,0
Xsky130_fd_sc_hd__fill_2_123 VSS VDD VDD sky130_fd_sc_hd__fill_2
* cell instance sky130_fd_sc_hd__fill_2_124 r0 *1 0,0
Xsky130_fd_sc_hd__fill_2_124 VSS VDD VDD sky130_fd_sc_hd__fill_2
* cell instance sky130_fd_sc_hd__fill_2_125 r0 *1 0,0
Xsky130_fd_sc_hd__fill_2_125 VSS VDD VDD sky130_fd_sc_hd__fill_2
* cell instance sky130_fd_sc_hd__fill_2_126 r0 *1 0,0
Xsky130_fd_sc_hd__fill_2_126 VSS VDD VDD sky130_fd_sc_hd__fill_2
* cell instance sky130_fd_sc_hd__fill_2_127 r0 *1 0,0
Xsky130_fd_sc_hd__fill_2_127 VSS VDD VDD sky130_fd_sc_hd__fill_2
* cell instance sky130_fd_sc_hd__fill_2_128 r0 *1 0,0
Xsky130_fd_sc_hd__fill_2_128 VSS VDD VDD sky130_fd_sc_hd__fill_2
* cell instance sky130_fd_sc_hd__fill_2_129 r0 *1 0,0
Xsky130_fd_sc_hd__fill_2_129 VSS VDD VDD sky130_fd_sc_hd__fill_2
* cell instance sky130_fd_sc_hd__fill_2_130 r0 *1 0,0
Xsky130_fd_sc_hd__fill_2_130 VSS VDD VDD sky130_fd_sc_hd__fill_2
* cell instance sky130_fd_sc_hd__fill_2_131 r0 *1 0,0
Xsky130_fd_sc_hd__fill_2_131 VSS VDD VDD sky130_fd_sc_hd__fill_2
* cell instance sky130_fd_sc_hd__fill_2_132 r0 *1 0,0
Xsky130_fd_sc_hd__fill_2_132 VSS VDD VDD sky130_fd_sc_hd__fill_2
* cell instance sky130_fd_sc_hd__fill_2_133 r0 *1 0,0
Xsky130_fd_sc_hd__fill_2_133 VSS VDD VDD sky130_fd_sc_hd__fill_2
* cell instance sky130_fd_sc_hd__fill_2_134 r0 *1 0,0
Xsky130_fd_sc_hd__fill_2_134 VSS VDD VDD sky130_fd_sc_hd__fill_2
* cell instance sky130_fd_sc_hd__fill_2_135 r0 *1 0,0
Xsky130_fd_sc_hd__fill_2_135 VSS VDD VDD sky130_fd_sc_hd__fill_2
* cell instance sky130_fd_sc_hd__fill_2_136 r0 *1 0,0
Xsky130_fd_sc_hd__fill_2_136 VSS VDD VDD sky130_fd_sc_hd__fill_2
* cell instance sky130_fd_sc_hd__fill_2_137 r0 *1 0,0
Xsky130_fd_sc_hd__fill_2_137 VSS VDD VDD sky130_fd_sc_hd__fill_2
* cell instance sky130_fd_sc_hd__fill_2_138 r0 *1 0,0
Xsky130_fd_sc_hd__fill_2_138 VSS VDD VDD sky130_fd_sc_hd__fill_2
* cell instance sky130_fd_sc_hd__fill_2_139 r0 *1 0,0
Xsky130_fd_sc_hd__fill_2_139 VSS VDD VDD sky130_fd_sc_hd__fill_2
* cell instance sky130_fd_sc_hd__fill_2_140 r0 *1 0,0
Xsky130_fd_sc_hd__fill_2_140 VSS VDD VDD sky130_fd_sc_hd__fill_2
* cell instance sky130_fd_sc_hd__fill_2_141 r0 *1 0,0
Xsky130_fd_sc_hd__fill_2_141 VSS VDD VDD sky130_fd_sc_hd__fill_2
* cell instance sky130_fd_sc_hd__fill_2_142 r0 *1 0,0
Xsky130_fd_sc_hd__fill_2_142 VSS VDD VDD sky130_fd_sc_hd__fill_2
* cell instance sky130_fd_sc_hd__fill_2_143 r0 *1 0,0
Xsky130_fd_sc_hd__fill_2_143 VSS VDD VDD sky130_fd_sc_hd__fill_2
* cell instance sky130_fd_sc_hd__fill_2_144 r0 *1 0,0
Xsky130_fd_sc_hd__fill_2_144 VSS VDD VDD sky130_fd_sc_hd__fill_2
* cell instance sky130_fd_sc_hd__fill_2_145 r0 *1 0,0
Xsky130_fd_sc_hd__fill_2_145 VSS VDD VDD sky130_fd_sc_hd__fill_2
* cell instance sky130_fd_sc_hd__fill_2_146 r0 *1 0,0
Xsky130_fd_sc_hd__fill_2_146 VSS VDD VDD sky130_fd_sc_hd__fill_2
* cell instance sky130_fd_sc_hd__fill_2_147 r0 *1 0,0
Xsky130_fd_sc_hd__fill_2_147 VSS VDD VDD sky130_fd_sc_hd__fill_2
* cell instance sky130_fd_sc_hd__fill_2_148 r0 *1 0,0
Xsky130_fd_sc_hd__fill_2_148 VSS VDD VDD sky130_fd_sc_hd__fill_2
* cell instance sky130_fd_sc_hd__fill_2_149 r0 *1 0,0
Xsky130_fd_sc_hd__fill_2_149 VSS VDD VDD sky130_fd_sc_hd__fill_2
* cell instance sky130_fd_sc_hd__fill_2_150 r0 *1 0,0
Xsky130_fd_sc_hd__fill_2_150 VSS VDD VDD sky130_fd_sc_hd__fill_2
* cell instance sky130_fd_sc_hd__fill_2_151 r0 *1 0,0
Xsky130_fd_sc_hd__fill_2_151 VSS VDD VDD sky130_fd_sc_hd__fill_2
* cell instance sky130_fd_sc_hd__fill_2_152 r0 *1 0,0
Xsky130_fd_sc_hd__fill_2_152 VSS VDD VDD sky130_fd_sc_hd__fill_2
* cell instance sky130_fd_sc_hd__fill_2_153 r0 *1 0,0
Xsky130_fd_sc_hd__fill_2_153 VSS VDD VDD sky130_fd_sc_hd__fill_2
* cell instance sky130_fd_sc_hd__fill_2_154 r0 *1 0,0
Xsky130_fd_sc_hd__fill_2_154 VSS VDD VDD sky130_fd_sc_hd__fill_2
* cell instance sky130_fd_sc_hd__fill_2_155 r0 *1 0,0
Xsky130_fd_sc_hd__fill_2_155 VSS VDD VDD sky130_fd_sc_hd__fill_2
* cell instance sky130_fd_sc_hd__fill_2_156 r0 *1 0,0
Xsky130_fd_sc_hd__fill_2_156 VSS VDD VDD sky130_fd_sc_hd__fill_2
* cell instance sky130_fd_sc_hd__fill_2_157 r0 *1 0,0
Xsky130_fd_sc_hd__fill_2_157 VSS VDD VDD sky130_fd_sc_hd__fill_2
* cell instance sky130_fd_sc_hd__fill_2_158 r0 *1 0,0
Xsky130_fd_sc_hd__fill_2_158 VSS VDD VDD sky130_fd_sc_hd__fill_2
* cell instance sky130_fd_sc_hd__fill_2_159 r0 *1 0,0
Xsky130_fd_sc_hd__fill_2_159 VSS VDD VDD sky130_fd_sc_hd__fill_2
* cell instance sky130_fd_sc_hd__fill_2_160 r0 *1 0,0
Xsky130_fd_sc_hd__fill_2_160 VSS VDD VDD sky130_fd_sc_hd__fill_2
* cell instance sky130_fd_sc_hd__fill_2_161 r0 *1 0,0
Xsky130_fd_sc_hd__fill_2_161 VSS VDD VDD sky130_fd_sc_hd__fill_2
* cell instance sky130_fd_sc_hd__fill_2_162 r0 *1 0,0
Xsky130_fd_sc_hd__fill_2_162 VSS VDD VDD sky130_fd_sc_hd__fill_2
* cell instance sky130_fd_sc_hd__fill_2_163 r0 *1 0,0
Xsky130_fd_sc_hd__fill_2_163 VSS VDD VDD sky130_fd_sc_hd__fill_2
* cell instance sky130_fd_sc_hd__fill_2_164 r0 *1 0,0
Xsky130_fd_sc_hd__fill_2_164 VSS VDD VDD sky130_fd_sc_hd__fill_2
* cell instance sky130_fd_sc_hd__fill_2_165 r0 *1 0,0
Xsky130_fd_sc_hd__fill_2_165 VSS VDD VDD sky130_fd_sc_hd__fill_2
* cell instance sky130_fd_sc_hd__fill_2_166 r0 *1 0,0
Xsky130_fd_sc_hd__fill_2_166 VSS VDD VDD sky130_fd_sc_hd__fill_2
* cell instance sky130_fd_sc_hd__fill_2_167 r0 *1 0,0
Xsky130_fd_sc_hd__fill_2_167 VSS VDD VDD sky130_fd_sc_hd__fill_2
* cell instance sky130_fd_sc_hd__fill_2_168 r0 *1 0,0
Xsky130_fd_sc_hd__fill_2_168 VSS VDD VDD sky130_fd_sc_hd__fill_2
* cell instance sky130_fd_sc_hd__fill_2_169 r0 *1 0,0
Xsky130_fd_sc_hd__fill_2_169 VSS VDD VDD sky130_fd_sc_hd__fill_2
* cell instance sky130_fd_sc_hd__fill_2_170 r0 *1 0,0
Xsky130_fd_sc_hd__fill_2_170 VSS VDD VDD sky130_fd_sc_hd__fill_2
* cell instance sky130_fd_sc_hd__fill_2_171 r0 *1 0,0
Xsky130_fd_sc_hd__fill_2_171 VSS VDD VDD sky130_fd_sc_hd__fill_2
* cell instance sky130_fd_sc_hd__fill_2_172 r0 *1 0,0
Xsky130_fd_sc_hd__fill_2_172 VSS VDD VDD sky130_fd_sc_hd__fill_2
* cell instance sky130_fd_sc_hd__fill_2_173 r0 *1 0,0
Xsky130_fd_sc_hd__fill_2_173 VSS VDD VDD sky130_fd_sc_hd__fill_2
* cell instance sky130_fd_sc_hd__fill_2_174 r0 *1 0,0
Xsky130_fd_sc_hd__fill_2_174 VSS VDD VDD sky130_fd_sc_hd__fill_2
* cell instance sky130_fd_sc_hd__fill_2_175 r0 *1 0,0
Xsky130_fd_sc_hd__fill_2_175 VSS VDD VDD sky130_fd_sc_hd__fill_2
* cell instance sky130_fd_sc_hd__fill_2_176 r0 *1 0,0
Xsky130_fd_sc_hd__fill_2_176 VSS VDD VDD sky130_fd_sc_hd__fill_2
* cell instance sky130_fd_sc_hd__fill_2_177 r0 *1 0,0
Xsky130_fd_sc_hd__fill_2_177 VSS VDD VDD sky130_fd_sc_hd__fill_2
* cell instance sky130_fd_sc_hd__fill_2_178 r0 *1 0,0
Xsky130_fd_sc_hd__fill_2_178 VSS VDD VDD sky130_fd_sc_hd__fill_2
* cell instance sky130_fd_sc_hd__fill_2_179 r0 *1 0,0
Xsky130_fd_sc_hd__fill_2_179 VSS VDD VDD sky130_fd_sc_hd__fill_2
* cell instance sky130_fd_sc_hd__fill_2_180 r0 *1 0,0
Xsky130_fd_sc_hd__fill_2_180 VSS VDD VDD sky130_fd_sc_hd__fill_2
* cell instance sky130_fd_sc_hd__fill_2_181 r0 *1 0,0
Xsky130_fd_sc_hd__fill_2_181 VSS VDD VDD sky130_fd_sc_hd__fill_2
* cell instance sky130_fd_sc_hd__fill_2_182 r0 *1 0,0
Xsky130_fd_sc_hd__fill_2_182 VSS VDD VDD sky130_fd_sc_hd__fill_2
* cell instance sky130_fd_sc_hd__fill_2_183 r0 *1 0,0
Xsky130_fd_sc_hd__fill_2_183 VSS VDD VDD sky130_fd_sc_hd__fill_2
* cell instance sky130_fd_sc_hd__fill_2_184 r0 *1 0,0
Xsky130_fd_sc_hd__fill_2_184 VSS VDD VDD sky130_fd_sc_hd__fill_2
* cell instance sky130_fd_sc_hd__fill_2_185 r0 *1 0,0
Xsky130_fd_sc_hd__fill_2_185 VSS VDD VDD sky130_fd_sc_hd__fill_2
* cell instance sky130_fd_sc_hd__fill_2_186 r0 *1 0,0
Xsky130_fd_sc_hd__fill_2_186 VSS VDD VDD sky130_fd_sc_hd__fill_2
* cell instance sky130_fd_sc_hd__fill_2_187 r0 *1 0,0
Xsky130_fd_sc_hd__fill_2_187 VSS VDD VDD sky130_fd_sc_hd__fill_2
* cell instance sky130_fd_sc_hd__fill_2_188 r0 *1 0,0
Xsky130_fd_sc_hd__fill_2_188 VSS VDD VDD sky130_fd_sc_hd__fill_2
* cell instance sky130_fd_sc_hd__fill_2_189 r0 *1 0,0
Xsky130_fd_sc_hd__fill_2_189 VSS VDD VDD sky130_fd_sc_hd__fill_2
* cell instance sky130_fd_sc_hd__fill_2_190 r0 *1 0,0
Xsky130_fd_sc_hd__fill_2_190 VSS VDD VDD sky130_fd_sc_hd__fill_2
* cell instance sky130_fd_sc_hd__fill_2_191 r0 *1 0,0
Xsky130_fd_sc_hd__fill_2_191 VSS VDD VDD sky130_fd_sc_hd__fill_2
* cell instance sky130_fd_sc_hd__fill_2_192 r0 *1 0,0
Xsky130_fd_sc_hd__fill_2_192 VSS VDD VDD sky130_fd_sc_hd__fill_2
* cell instance sky130_fd_sc_hd__fill_2_193 r0 *1 0,0
Xsky130_fd_sc_hd__fill_2_193 VSS VDD VDD sky130_fd_sc_hd__fill_2
* cell instance sky130_fd_sc_hd__fill_2_194 r0 *1 0,0
Xsky130_fd_sc_hd__fill_2_194 VSS VDD VDD sky130_fd_sc_hd__fill_2
* cell instance sky130_fd_sc_hd__fill_2_195 r0 *1 0,0
Xsky130_fd_sc_hd__fill_2_195 VSS VDD VDD sky130_fd_sc_hd__fill_2
* cell instance sky130_fd_sc_hd__fill_2_196 r0 *1 0,0
Xsky130_fd_sc_hd__fill_2_196 VSS VDD VDD sky130_fd_sc_hd__fill_2
* cell instance sky130_fd_sc_hd__fill_2_197 r0 *1 0,0
Xsky130_fd_sc_hd__fill_2_197 VSS VDD VDD sky130_fd_sc_hd__fill_2
* cell instance sky130_fd_sc_hd__fill_2_198 r0 *1 0,0
Xsky130_fd_sc_hd__fill_2_198 VSS VDD VDD sky130_fd_sc_hd__fill_2
* cell instance sky130_fd_sc_hd__fill_2_199 r0 *1 0,0
Xsky130_fd_sc_hd__fill_2_199 VSS VDD VDD sky130_fd_sc_hd__fill_2
* cell instance sky130_fd_sc_hd__fill_2_200 r0 *1 0,0
Xsky130_fd_sc_hd__fill_2_200 VSS VDD VDD sky130_fd_sc_hd__fill_2
* cell instance sky130_fd_sc_hd__fill_2_201 r0 *1 0,0
Xsky130_fd_sc_hd__fill_2_201 VSS VDD VDD sky130_fd_sc_hd__fill_2
* cell instance sky130_fd_sc_hd__fill_2_202 r0 *1 0,0
Xsky130_fd_sc_hd__fill_2_202 VSS VDD VDD sky130_fd_sc_hd__fill_2
* cell instance sky130_fd_sc_hd__fill_2_203 r0 *1 0,0
Xsky130_fd_sc_hd__fill_2_203 VSS VDD VDD sky130_fd_sc_hd__fill_2
* cell instance sky130_fd_sc_hd__fill_2_204 r0 *1 0,0
Xsky130_fd_sc_hd__fill_2_204 VSS VDD VDD sky130_fd_sc_hd__fill_2
* cell instance sky130_fd_sc_hd__fill_2_205 r0 *1 0,0
Xsky130_fd_sc_hd__fill_2_205 VSS VDD VDD sky130_fd_sc_hd__fill_2
* cell instance sky130_fd_sc_hd__fill_2_206 r0 *1 0,0
Xsky130_fd_sc_hd__fill_2_206 VSS VDD VDD sky130_fd_sc_hd__fill_2
* cell instance sky130_fd_sc_hd__fill_2_207 r0 *1 0,0
Xsky130_fd_sc_hd__fill_2_207 VSS VDD VDD sky130_fd_sc_hd__fill_2
* cell instance sky130_fd_sc_hd__fill_2_208 r0 *1 0,0
Xsky130_fd_sc_hd__fill_2_208 VSS VDD VDD sky130_fd_sc_hd__fill_2
* cell instance sky130_fd_sc_hd__fill_2_209 r0 *1 0,0
Xsky130_fd_sc_hd__fill_2_209 VSS VDD VDD sky130_fd_sc_hd__fill_2
* cell instance sky130_fd_sc_hd__fill_2_210 r0 *1 0,0
Xsky130_fd_sc_hd__fill_2_210 VSS VDD VDD sky130_fd_sc_hd__fill_2
* cell instance sky130_fd_sc_hd__fill_2_211 r0 *1 0,0
Xsky130_fd_sc_hd__fill_2_211 VSS VDD VDD sky130_fd_sc_hd__fill_2
* cell instance sky130_fd_sc_hd__fill_2_212 r0 *1 0,0
Xsky130_fd_sc_hd__fill_2_212 VSS VDD VDD sky130_fd_sc_hd__fill_2
* cell instance sky130_fd_sc_hd__fill_2_213 r0 *1 0,0
Xsky130_fd_sc_hd__fill_2_213 VSS VDD VDD sky130_fd_sc_hd__fill_2
* cell instance sky130_fd_sc_hd__fill_2_214 r0 *1 0,0
Xsky130_fd_sc_hd__fill_2_214 VSS VDD VDD sky130_fd_sc_hd__fill_2
* cell instance sky130_fd_sc_hd__fill_2_215 r0 *1 0,0
Xsky130_fd_sc_hd__fill_2_215 VSS VDD VDD sky130_fd_sc_hd__fill_2
* cell instance sky130_fd_sc_hd__fill_2_216 r0 *1 0,0
Xsky130_fd_sc_hd__fill_2_216 VSS VDD VDD sky130_fd_sc_hd__fill_2
* cell instance sky130_fd_sc_hd__fill_2_217 r0 *1 0,0
Xsky130_fd_sc_hd__fill_2_217 VSS VDD VDD sky130_fd_sc_hd__fill_2
* cell instance sky130_fd_sc_hd__fill_2_218 r0 *1 0,0
Xsky130_fd_sc_hd__fill_2_218 VSS VDD VDD sky130_fd_sc_hd__fill_2
* cell instance sky130_fd_sc_hd__fill_2_219 r0 *1 0,0
Xsky130_fd_sc_hd__fill_2_219 VSS VDD VDD sky130_fd_sc_hd__fill_2
* cell instance sky130_fd_sc_hd__fill_2_220 r0 *1 0,0
Xsky130_fd_sc_hd__fill_2_220 VSS VDD VDD sky130_fd_sc_hd__fill_2
* cell instance sky130_fd_sc_hd__fill_2_221 r0 *1 0,0
Xsky130_fd_sc_hd__fill_2_221 VSS VDD VDD sky130_fd_sc_hd__fill_2
* cell instance sky130_fd_sc_hd__fill_2_222 r0 *1 0,0
Xsky130_fd_sc_hd__fill_2_222 VSS VDD VDD sky130_fd_sc_hd__fill_2
* cell instance sky130_fd_sc_hd__fill_2_223 r0 *1 0,0
Xsky130_fd_sc_hd__fill_2_223 VSS VDD VDD sky130_fd_sc_hd__fill_2
* cell instance sky130_fd_sc_hd__fill_2_224 r0 *1 0,0
Xsky130_fd_sc_hd__fill_2_224 VSS VDD VDD sky130_fd_sc_hd__fill_2
* cell instance sky130_fd_sc_hd__fill_2_225 r0 *1 0,0
Xsky130_fd_sc_hd__fill_2_225 VSS VDD VDD sky130_fd_sc_hd__fill_2
* cell instance sky130_fd_sc_hd__fill_2_226 r0 *1 0,0
Xsky130_fd_sc_hd__fill_2_226 VSS VDD VDD sky130_fd_sc_hd__fill_2
* cell instance sky130_fd_sc_hd__fill_2_227 r0 *1 0,0
Xsky130_fd_sc_hd__fill_2_227 VSS VDD VDD sky130_fd_sc_hd__fill_2
* cell instance sky130_fd_sc_hd__fill_2_228 r0 *1 0,0
Xsky130_fd_sc_hd__fill_2_228 VSS VDD VDD sky130_fd_sc_hd__fill_2
* cell instance sky130_fd_sc_hd__fill_2_229 r0 *1 0,0
Xsky130_fd_sc_hd__fill_2_229 VSS VDD VDD sky130_fd_sc_hd__fill_2
* cell instance sky130_fd_sc_hd__fill_2_230 r0 *1 0,0
Xsky130_fd_sc_hd__fill_2_230 VSS VDD VDD sky130_fd_sc_hd__fill_2
* cell instance sky130_fd_sc_hd__fill_2_231 r0 *1 0,0
Xsky130_fd_sc_hd__fill_2_231 VSS VDD VDD sky130_fd_sc_hd__fill_2
* cell instance sky130_fd_sc_hd__fill_2_232 r0 *1 0,0
Xsky130_fd_sc_hd__fill_2_232 VSS VDD VDD sky130_fd_sc_hd__fill_2
* cell instance sky130_fd_sc_hd__fill_2_233 r0 *1 0,0
Xsky130_fd_sc_hd__fill_2_233 VSS VDD VDD sky130_fd_sc_hd__fill_2
* cell instance sky130_fd_sc_hd__fill_2_234 r0 *1 0,0
Xsky130_fd_sc_hd__fill_2_234 VSS VDD VDD sky130_fd_sc_hd__fill_2
* cell instance sky130_fd_sc_hd__fill_2_235 r0 *1 0,0
Xsky130_fd_sc_hd__fill_2_235 VSS VDD VDD sky130_fd_sc_hd__fill_2
* cell instance sky130_fd_sc_hd__fill_2_236 r0 *1 0,0
Xsky130_fd_sc_hd__fill_2_236 VSS VDD VDD sky130_fd_sc_hd__fill_2
* cell instance sky130_fd_sc_hd__fill_2_237 r0 *1 0,0
Xsky130_fd_sc_hd__fill_2_237 VSS VDD VDD sky130_fd_sc_hd__fill_2
* cell instance sky130_fd_sc_hd__fill_2_238 r0 *1 0,0
Xsky130_fd_sc_hd__fill_2_238 VSS VDD VDD sky130_fd_sc_hd__fill_2
* cell instance sky130_fd_sc_hd__fill_2_239 r0 *1 0,0
Xsky130_fd_sc_hd__fill_2_239 VSS VDD VDD sky130_fd_sc_hd__fill_2
* cell instance sky130_fd_sc_hd__fill_2_240 r0 *1 0,0
Xsky130_fd_sc_hd__fill_2_240 VSS VDD VDD sky130_fd_sc_hd__fill_2
* cell instance sky130_fd_sc_hd__fill_2_241 r0 *1 0,0
Xsky130_fd_sc_hd__fill_2_241 VSS VDD VDD sky130_fd_sc_hd__fill_2
* cell instance sky130_fd_sc_hd__fill_2_242 r0 *1 0,0
Xsky130_fd_sc_hd__fill_2_242 VSS VDD VDD sky130_fd_sc_hd__fill_2
* cell instance sky130_fd_sc_hd__fill_2_243 r0 *1 0,0
Xsky130_fd_sc_hd__fill_2_243 VSS VDD VDD sky130_fd_sc_hd__fill_2
* cell instance sky130_fd_sc_hd__fill_2_244 r0 *1 0,0
Xsky130_fd_sc_hd__fill_2_244 VSS VDD VDD sky130_fd_sc_hd__fill_2
* cell instance sky130_fd_sc_hd__fill_2_245 r0 *1 0,0
Xsky130_fd_sc_hd__fill_2_245 VSS VDD VDD sky130_fd_sc_hd__fill_2
* cell instance sky130_fd_sc_hd__fill_2_246 r0 *1 0,0
Xsky130_fd_sc_hd__fill_2_246 VSS VDD VDD sky130_fd_sc_hd__fill_2
* cell instance sky130_fd_sc_hd__fill_2_247 r0 *1 0,0
Xsky130_fd_sc_hd__fill_2_247 VSS VDD VDD sky130_fd_sc_hd__fill_2
* cell instance sky130_fd_sc_hd__fill_2_248 r0 *1 0,0
Xsky130_fd_sc_hd__fill_2_248 VSS VDD VDD sky130_fd_sc_hd__fill_2
* cell instance sky130_fd_sc_hd__fill_2_249 r0 *1 0,0
Xsky130_fd_sc_hd__fill_2_249 VSS VDD VDD sky130_fd_sc_hd__fill_2
* cell instance sky130_fd_sc_hd__fill_2_250 r0 *1 0,0
Xsky130_fd_sc_hd__fill_2_250 VSS VDD VDD sky130_fd_sc_hd__fill_2
* cell instance sky130_fd_sc_hd__fill_2_251 r0 *1 0,0
Xsky130_fd_sc_hd__fill_2_251 VSS VDD VDD sky130_fd_sc_hd__fill_2
* cell instance sky130_fd_sc_hd__fill_2_252 r0 *1 0,0
Xsky130_fd_sc_hd__fill_2_252 VSS VDD VDD sky130_fd_sc_hd__fill_2
* cell instance sky130_fd_sc_hd__fill_2_253 r0 *1 0,0
Xsky130_fd_sc_hd__fill_2_253 VSS VDD VDD sky130_fd_sc_hd__fill_2
* cell instance sky130_fd_sc_hd__fill_2_254 r0 *1 0,0
Xsky130_fd_sc_hd__fill_2_254 VSS VDD VDD sky130_fd_sc_hd__fill_2
* cell instance sky130_fd_sc_hd__fill_2_255 r0 *1 0,0
Xsky130_fd_sc_hd__fill_2_255 VSS VDD VDD sky130_fd_sc_hd__fill_2
* cell instance sky130_fd_sc_hd__fill_2_256 r0 *1 0,0
Xsky130_fd_sc_hd__fill_2_256 VSS VDD VDD sky130_fd_sc_hd__fill_2
* cell instance sky130_fd_sc_hd__fill_2_257 r0 *1 0,0
Xsky130_fd_sc_hd__fill_2_257 VSS VDD VDD sky130_fd_sc_hd__fill_2
* cell instance sky130_fd_sc_hd__fill_2_258 r0 *1 0,0
Xsky130_fd_sc_hd__fill_2_258 VSS VDD VDD sky130_fd_sc_hd__fill_2
* cell instance sky130_fd_sc_hd__fill_2_259 r0 *1 0,0
Xsky130_fd_sc_hd__fill_2_259 VSS VDD VDD sky130_fd_sc_hd__fill_2
* cell instance sky130_fd_sc_hd__fill_2_260 r0 *1 0,0
Xsky130_fd_sc_hd__fill_2_260 VSS VDD VDD sky130_fd_sc_hd__fill_2
* cell instance sky130_fd_sc_hd__fill_2_261 r0 *1 0,0
Xsky130_fd_sc_hd__fill_2_261 VSS VDD VDD sky130_fd_sc_hd__fill_2
* cell instance sky130_fd_sc_hd__fill_2_262 r0 *1 0,0
Xsky130_fd_sc_hd__fill_2_262 VSS VDD VDD sky130_fd_sc_hd__fill_2
* cell instance sky130_fd_sc_hd__fill_2_263 r0 *1 0,0
Xsky130_fd_sc_hd__fill_2_263 VSS VDD VDD sky130_fd_sc_hd__fill_2
* cell instance sky130_fd_sc_hd__fill_2_264 r0 *1 0,0
Xsky130_fd_sc_hd__fill_2_264 VSS VDD VDD sky130_fd_sc_hd__fill_2
* cell instance sky130_fd_sc_hd__fill_2_265 r0 *1 0,0
Xsky130_fd_sc_hd__fill_2_265 VSS VDD VDD sky130_fd_sc_hd__fill_2
* cell instance sky130_fd_sc_hd__fill_2_266 r0 *1 0,0
Xsky130_fd_sc_hd__fill_2_266 VSS VDD VDD sky130_fd_sc_hd__fill_2
* cell instance sky130_fd_sc_hd__fill_2_267 r0 *1 0,0
Xsky130_fd_sc_hd__fill_2_267 VSS VDD VDD sky130_fd_sc_hd__fill_2
* cell instance sky130_fd_sc_hd__fill_2_268 r0 *1 0,0
Xsky130_fd_sc_hd__fill_2_268 VSS VDD VDD sky130_fd_sc_hd__fill_2
* cell instance sky130_fd_sc_hd__fill_2_269 r0 *1 0,0
Xsky130_fd_sc_hd__fill_2_269 VSS VDD VDD sky130_fd_sc_hd__fill_2
* cell instance sky130_fd_sc_hd__fill_2_270 r0 *1 0,0
Xsky130_fd_sc_hd__fill_2_270 VSS VDD VDD sky130_fd_sc_hd__fill_2
* cell instance sky130_fd_sc_hd__fill_2_271 r0 *1 0,0
Xsky130_fd_sc_hd__fill_2_271 VSS VDD VDD sky130_fd_sc_hd__fill_2
* cell instance sky130_fd_sc_hd__fill_2_272 r0 *1 0,0
Xsky130_fd_sc_hd__fill_2_272 VSS VDD VDD sky130_fd_sc_hd__fill_2
* cell instance sky130_fd_sc_hd__fill_2_273 r0 *1 0,0
Xsky130_fd_sc_hd__fill_2_273 VSS VDD VDD sky130_fd_sc_hd__fill_2
* cell instance sky130_fd_sc_hd__fill_2_274 r0 *1 0,0
Xsky130_fd_sc_hd__fill_2_274 VSS VDD VDD sky130_fd_sc_hd__fill_2
* cell instance sky130_fd_sc_hd__fill_2_275 r0 *1 0,0
Xsky130_fd_sc_hd__fill_2_275 VSS VDD VDD sky130_fd_sc_hd__fill_2
* cell instance sky130_fd_sc_hd__fill_2_276 r0 *1 0,0
Xsky130_fd_sc_hd__fill_2_276 VSS VDD VDD sky130_fd_sc_hd__fill_2
* cell instance sky130_fd_sc_hd__fill_2_277 r0 *1 0,0
Xsky130_fd_sc_hd__fill_2_277 VSS VDD VDD sky130_fd_sc_hd__fill_2
* cell instance sky130_fd_sc_hd__fill_2_278 r0 *1 0,0
Xsky130_fd_sc_hd__fill_2_278 VSS VDD VDD sky130_fd_sc_hd__fill_2
* cell instance sky130_fd_sc_hd__fill_2_279 r0 *1 0,0
Xsky130_fd_sc_hd__fill_2_279 VSS VDD VDD sky130_fd_sc_hd__fill_2
* cell instance sky130_fd_sc_hd__fill_2_280 r0 *1 0,0
Xsky130_fd_sc_hd__fill_2_280 VSS VDD VDD sky130_fd_sc_hd__fill_2
* cell instance sky130_fd_sc_hd__fill_2_281 r0 *1 0,0
Xsky130_fd_sc_hd__fill_2_281 VSS VDD VDD sky130_fd_sc_hd__fill_2
* cell instance sky130_fd_sc_hd__fill_2_282 r0 *1 0,0
Xsky130_fd_sc_hd__fill_2_282 VSS VDD VDD sky130_fd_sc_hd__fill_2
* cell instance sky130_fd_sc_hd__fill_2_283 r0 *1 0,0
Xsky130_fd_sc_hd__fill_2_283 VSS VDD VDD sky130_fd_sc_hd__fill_2
* cell instance sky130_fd_sc_hd__fill_2_284 r0 *1 0,0
Xsky130_fd_sc_hd__fill_2_284 VSS VDD VDD sky130_fd_sc_hd__fill_2
* cell instance sky130_fd_sc_hd__fill_2_285 r0 *1 0,0
Xsky130_fd_sc_hd__fill_2_285 VSS VDD VDD sky130_fd_sc_hd__fill_2
* cell instance sky130_fd_sc_hd__fill_2_286 r0 *1 0,0
Xsky130_fd_sc_hd__fill_2_286 VSS VDD VDD sky130_fd_sc_hd__fill_2
* cell instance sky130_fd_sc_hd__fill_2_287 r0 *1 0,0
Xsky130_fd_sc_hd__fill_2_287 VSS VDD VDD sky130_fd_sc_hd__fill_2
* cell instance sky130_fd_sc_hd__fill_2_288 r0 *1 0,0
Xsky130_fd_sc_hd__fill_2_288 VSS VDD VDD sky130_fd_sc_hd__fill_2
* cell instance sky130_fd_sc_hd__fill_2_289 r0 *1 0,0
Xsky130_fd_sc_hd__fill_2_289 VSS VDD VDD sky130_fd_sc_hd__fill_2
* cell instance sky130_fd_sc_hd__fill_2_290 r0 *1 0,0
Xsky130_fd_sc_hd__fill_2_290 VSS VDD VDD sky130_fd_sc_hd__fill_2
* cell instance sky130_fd_sc_hd__fill_2_291 r0 *1 0,0
Xsky130_fd_sc_hd__fill_2_291 VSS VDD VDD sky130_fd_sc_hd__fill_2
* cell instance sky130_fd_sc_hd__fill_2_292 r0 *1 0,0
Xsky130_fd_sc_hd__fill_2_292 VSS VDD VDD sky130_fd_sc_hd__fill_2
* cell instance sky130_fd_sc_hd__fill_2_293 r0 *1 0,0
Xsky130_fd_sc_hd__fill_2_293 VSS VDD VDD sky130_fd_sc_hd__fill_2
* cell instance sky130_fd_sc_hd__fill_2_294 r0 *1 0,0
Xsky130_fd_sc_hd__fill_2_294 VSS VDD VDD sky130_fd_sc_hd__fill_2
* cell instance sky130_fd_sc_hd__fill_2_295 r0 *1 0,0
Xsky130_fd_sc_hd__fill_2_295 VSS VDD VDD sky130_fd_sc_hd__fill_2
* cell instance sky130_fd_sc_hd__fill_2_296 r0 *1 0,0
Xsky130_fd_sc_hd__fill_2_296 VSS VDD VDD sky130_fd_sc_hd__fill_2
* cell instance sky130_fd_sc_hd__fill_2_297 r0 *1 0,0
Xsky130_fd_sc_hd__fill_2_297 VSS VDD VDD sky130_fd_sc_hd__fill_2
* cell instance sky130_fd_sc_hd__fill_2_298 r0 *1 0,0
Xsky130_fd_sc_hd__fill_2_298 VSS VDD VDD sky130_fd_sc_hd__fill_2
* cell instance sky130_fd_sc_hd__fill_2_299 r0 *1 0,0
Xsky130_fd_sc_hd__fill_2_299 VSS VDD VDD sky130_fd_sc_hd__fill_2
* cell instance sky130_fd_sc_hd__fill_2_300 r0 *1 0,0
Xsky130_fd_sc_hd__fill_2_300 VSS VDD VDD sky130_fd_sc_hd__fill_2
* cell instance sky130_fd_sc_hd__fill_2_301 r0 *1 0,0
Xsky130_fd_sc_hd__fill_2_301 VSS VDD VDD sky130_fd_sc_hd__fill_2
* cell instance sky130_fd_sc_hd__fill_2_302 r0 *1 0,0
Xsky130_fd_sc_hd__fill_2_302 VSS VDD VDD sky130_fd_sc_hd__fill_2
* cell instance sky130_fd_sc_hd__fill_2_303 r0 *1 0,0
Xsky130_fd_sc_hd__fill_2_303 VSS VDD VDD sky130_fd_sc_hd__fill_2
* cell instance sky130_fd_sc_hd__fill_2_304 r0 *1 0,0
Xsky130_fd_sc_hd__fill_2_304 VSS VDD VDD sky130_fd_sc_hd__fill_2
* cell instance sky130_fd_sc_hd__fill_2_305 r0 *1 0,0
Xsky130_fd_sc_hd__fill_2_305 VSS VDD VDD sky130_fd_sc_hd__fill_2
* cell instance sky130_fd_sc_hd__fill_2_306 r0 *1 0,0
Xsky130_fd_sc_hd__fill_2_306 VSS VDD VDD sky130_fd_sc_hd__fill_2
* cell instance sky130_fd_sc_hd__fill_2_307 r0 *1 0,0
Xsky130_fd_sc_hd__fill_2_307 VSS VDD VDD sky130_fd_sc_hd__fill_2
* cell instance sky130_fd_sc_hd__fill_2_308 r0 *1 0,0
Xsky130_fd_sc_hd__fill_2_308 VSS VDD VDD sky130_fd_sc_hd__fill_2
* cell instance sky130_fd_sc_hd__fill_2_309 r0 *1 0,0
Xsky130_fd_sc_hd__fill_2_309 VSS VDD VDD sky130_fd_sc_hd__fill_2
* cell instance sky130_fd_sc_hd__fill_2_310 r0 *1 0,0
Xsky130_fd_sc_hd__fill_2_310 VSS VDD VDD sky130_fd_sc_hd__fill_2
* cell instance sky130_fd_sc_hd__fill_2_311 r0 *1 0,0
Xsky130_fd_sc_hd__fill_2_311 VSS VDD VDD sky130_fd_sc_hd__fill_2
* cell instance sky130_fd_sc_hd__fill_2_312 r0 *1 0,0
Xsky130_fd_sc_hd__fill_2_312 VSS VDD VDD sky130_fd_sc_hd__fill_2
* cell instance sky130_fd_sc_hd__fill_2_313 r0 *1 0,0
Xsky130_fd_sc_hd__fill_2_313 VSS VDD VDD sky130_fd_sc_hd__fill_2
* cell instance sky130_fd_sc_hd__fill_2_314 r0 *1 0,0
Xsky130_fd_sc_hd__fill_2_314 VSS VDD VDD sky130_fd_sc_hd__fill_2
* cell instance sky130_fd_sc_hd__fill_2_315 r0 *1 0,0
Xsky130_fd_sc_hd__fill_2_315 VSS VDD VDD sky130_fd_sc_hd__fill_2
* cell instance sky130_fd_sc_hd__fill_2_316 r0 *1 0,0
Xsky130_fd_sc_hd__fill_2_316 VSS VDD VDD sky130_fd_sc_hd__fill_2
* cell instance sky130_fd_sc_hd__fill_2_317 r0 *1 0,0
Xsky130_fd_sc_hd__fill_2_317 VSS VDD VDD sky130_fd_sc_hd__fill_2
* cell instance sky130_fd_sc_hd__fill_2_318 r0 *1 0,0
Xsky130_fd_sc_hd__fill_2_318 VSS VDD VDD sky130_fd_sc_hd__fill_2
* cell instance sky130_fd_sc_hd__fill_2_319 r0 *1 0,0
Xsky130_fd_sc_hd__fill_2_319 VSS VDD VDD sky130_fd_sc_hd__fill_2
* cell instance sky130_fd_sc_hd__fill_2_320 r0 *1 0,0
Xsky130_fd_sc_hd__fill_2_320 VSS VDD VDD sky130_fd_sc_hd__fill_2
* cell instance sky130_fd_sc_hd__fill_2_321 r0 *1 0,0
Xsky130_fd_sc_hd__fill_2_321 VSS VDD VDD sky130_fd_sc_hd__fill_2
* cell instance sky130_fd_sc_hd__fill_2_322 r0 *1 0,0
Xsky130_fd_sc_hd__fill_2_322 VSS VDD VDD sky130_fd_sc_hd__fill_2
* cell instance sky130_fd_sc_hd__fill_2_323 r0 *1 0,0
Xsky130_fd_sc_hd__fill_2_323 VSS VDD VDD sky130_fd_sc_hd__fill_2
* cell instance sky130_fd_sc_hd__fill_2_324 r0 *1 0,0
Xsky130_fd_sc_hd__fill_2_324 VSS VDD VDD sky130_fd_sc_hd__fill_2
* cell instance sky130_fd_sc_hd__fill_2_325 r0 *1 0,0
Xsky130_fd_sc_hd__fill_2_325 VSS VDD VDD sky130_fd_sc_hd__fill_2
* cell instance sky130_fd_sc_hd__fill_2_326 r0 *1 0,0
Xsky130_fd_sc_hd__fill_2_326 VSS VDD VDD sky130_fd_sc_hd__fill_2
* cell instance sky130_fd_sc_hd__fill_2_327 r0 *1 0,0
Xsky130_fd_sc_hd__fill_2_327 VSS VDD VDD sky130_fd_sc_hd__fill_2
* cell instance sky130_fd_sc_hd__fill_2_328 r0 *1 0,0
Xsky130_fd_sc_hd__fill_2_328 VSS VDD VDD sky130_fd_sc_hd__fill_2
* cell instance sky130_fd_sc_hd__fill_2_329 r0 *1 0,0
Xsky130_fd_sc_hd__fill_2_329 VSS VDD VDD sky130_fd_sc_hd__fill_2
* cell instance sky130_fd_sc_hd__fill_2_330 r0 *1 0,0
Xsky130_fd_sc_hd__fill_2_330 VSS VDD VDD sky130_fd_sc_hd__fill_2
* cell instance sky130_fd_sc_hd__fill_2_331 r0 *1 0,0
Xsky130_fd_sc_hd__fill_2_331 VSS VDD VDD sky130_fd_sc_hd__fill_2
* cell instance sky130_fd_sc_hd__fill_2_332 r0 *1 0,0
Xsky130_fd_sc_hd__fill_2_332 VSS VDD VDD sky130_fd_sc_hd__fill_2
* cell instance sky130_fd_sc_hd__fill_2_333 r0 *1 0,0
Xsky130_fd_sc_hd__fill_2_333 VSS VDD VDD sky130_fd_sc_hd__fill_2
* cell instance sky130_fd_sc_hd__fill_2_334 r0 *1 0,0
Xsky130_fd_sc_hd__fill_2_334 VSS VDD VDD sky130_fd_sc_hd__fill_2
* cell instance sky130_fd_sc_hd__fill_2_335 r0 *1 0,0
Xsky130_fd_sc_hd__fill_2_335 VSS VDD VDD sky130_fd_sc_hd__fill_2
* cell instance sky130_fd_sc_hd__fill_2_336 r0 *1 0,0
Xsky130_fd_sc_hd__fill_2_336 VSS VDD VDD sky130_fd_sc_hd__fill_2
* cell instance sky130_fd_sc_hd__fill_2_337 r0 *1 0,0
Xsky130_fd_sc_hd__fill_2_337 VSS VDD VDD sky130_fd_sc_hd__fill_2
* cell instance sky130_fd_sc_hd__fill_2_338 r0 *1 0,0
Xsky130_fd_sc_hd__fill_2_338 VSS VDD VDD sky130_fd_sc_hd__fill_2
* cell instance sky130_fd_sc_hd__fill_2_339 r0 *1 0,0
Xsky130_fd_sc_hd__fill_2_339 VSS VDD VDD sky130_fd_sc_hd__fill_2
* cell instance sky130_fd_sc_hd__fill_2_340 r0 *1 0,0
Xsky130_fd_sc_hd__fill_2_340 VSS VDD VDD sky130_fd_sc_hd__fill_2
* cell instance sky130_fd_sc_hd__fill_2_341 r0 *1 0,0
Xsky130_fd_sc_hd__fill_2_341 VSS VDD VDD sky130_fd_sc_hd__fill_2
* cell instance sky130_fd_sc_hd__fill_2_342 r0 *1 0,0
Xsky130_fd_sc_hd__fill_2_342 VSS VDD VDD sky130_fd_sc_hd__fill_2
* cell instance sky130_fd_sc_hd__fill_2_343 r0 *1 0,0
Xsky130_fd_sc_hd__fill_2_343 VSS VDD VDD sky130_fd_sc_hd__fill_2
* cell instance sky130_fd_sc_hd__fill_2_344 r0 *1 0,0
Xsky130_fd_sc_hd__fill_2_344 VSS VDD VDD sky130_fd_sc_hd__fill_2
* cell instance sky130_fd_sc_hd__fill_2_345 r0 *1 0,0
Xsky130_fd_sc_hd__fill_2_345 VSS VDD VDD sky130_fd_sc_hd__fill_2
* cell instance sky130_fd_sc_hd__fill_2_346 r0 *1 0,0
Xsky130_fd_sc_hd__fill_2_346 VSS VDD VDD sky130_fd_sc_hd__fill_2
* cell instance sky130_fd_sc_hd__fill_2_347 r0 *1 0,0
Xsky130_fd_sc_hd__fill_2_347 VSS VDD VDD sky130_fd_sc_hd__fill_2
* cell instance sky130_fd_sc_hd__fill_2_348 r0 *1 0,0
Xsky130_fd_sc_hd__fill_2_348 VSS VDD VDD sky130_fd_sc_hd__fill_2
* cell instance sky130_fd_sc_hd__fill_2_349 r0 *1 0,0
Xsky130_fd_sc_hd__fill_2_349 VSS VDD VDD sky130_fd_sc_hd__fill_2
* cell instance sky130_fd_sc_hd__fill_2_350 r0 *1 0,0
Xsky130_fd_sc_hd__fill_2_350 VSS VDD VDD sky130_fd_sc_hd__fill_2
* cell instance sky130_fd_sc_hd__fill_2_351 r0 *1 0,0
Xsky130_fd_sc_hd__fill_2_351 VSS VDD VDD sky130_fd_sc_hd__fill_2
* cell instance sky130_fd_sc_hd__fill_2_352 r0 *1 0,0
Xsky130_fd_sc_hd__fill_2_352 VSS VDD VDD sky130_fd_sc_hd__fill_2
* cell instance sky130_fd_sc_hd__fill_2_353 r0 *1 0,0
Xsky130_fd_sc_hd__fill_2_353 VSS VDD VDD sky130_fd_sc_hd__fill_2
* cell instance sky130_fd_sc_hd__fill_2_354 r0 *1 0,0
Xsky130_fd_sc_hd__fill_2_354 VSS VDD VDD sky130_fd_sc_hd__fill_2
* cell instance sky130_fd_sc_hd__fill_2_355 r0 *1 0,0
Xsky130_fd_sc_hd__fill_2_355 VSS VDD VDD sky130_fd_sc_hd__fill_2
* cell instance sky130_fd_sc_hd__fill_2_356 r0 *1 0,0
Xsky130_fd_sc_hd__fill_2_356 VSS VDD VDD sky130_fd_sc_hd__fill_2
* cell instance sky130_fd_sc_hd__fill_2_357 r0 *1 0,0
Xsky130_fd_sc_hd__fill_2_357 VSS VDD VDD sky130_fd_sc_hd__fill_2
* cell instance sky130_fd_sc_hd__fill_2_358 r0 *1 0,0
Xsky130_fd_sc_hd__fill_2_358 VSS VDD VDD sky130_fd_sc_hd__fill_2
* cell instance sky130_fd_sc_hd__fill_2_359 r0 *1 0,0
Xsky130_fd_sc_hd__fill_2_359 VSS VDD VDD sky130_fd_sc_hd__fill_2
* cell instance sky130_fd_sc_hd__fill_2_360 r0 *1 0,0
Xsky130_fd_sc_hd__fill_2_360 VSS VDD VDD sky130_fd_sc_hd__fill_2
* cell instance sky130_fd_sc_hd__fill_2_361 r0 *1 0,0
Xsky130_fd_sc_hd__fill_2_361 VSS VDD VDD sky130_fd_sc_hd__fill_2
* cell instance sky130_fd_sc_hd__fill_2_362 r0 *1 0,0
Xsky130_fd_sc_hd__fill_2_362 VSS VDD VDD sky130_fd_sc_hd__fill_2
* cell instance sky130_fd_sc_hd__fill_2_363 r0 *1 0,0
Xsky130_fd_sc_hd__fill_2_363 VSS VDD VDD sky130_fd_sc_hd__fill_2
* cell instance sky130_fd_sc_hd__fill_2_364 r0 *1 0,0
Xsky130_fd_sc_hd__fill_2_364 VSS VDD VDD sky130_fd_sc_hd__fill_2
* cell instance sky130_fd_sc_hd__fill_2_365 r0 *1 0,0
Xsky130_fd_sc_hd__fill_2_365 VSS VDD VDD sky130_fd_sc_hd__fill_2
* cell instance sky130_fd_sc_hd__fill_2_366 r0 *1 0,0
Xsky130_fd_sc_hd__fill_2_366 VSS VDD VDD sky130_fd_sc_hd__fill_2
* cell instance sky130_fd_sc_hd__fill_2_367 r0 *1 0,0
Xsky130_fd_sc_hd__fill_2_367 VSS VDD VDD sky130_fd_sc_hd__fill_2
* cell instance sky130_fd_sc_hd__fill_2_368 r0 *1 0,0
Xsky130_fd_sc_hd__fill_2_368 VSS VDD VDD sky130_fd_sc_hd__fill_2
* cell instance sky130_fd_sc_hd__fill_2_369 r0 *1 0,0
Xsky130_fd_sc_hd__fill_2_369 VSS VDD VDD sky130_fd_sc_hd__fill_2
* cell instance sky130_fd_sc_hd__fill_2_370 r0 *1 0,0
Xsky130_fd_sc_hd__fill_2_370 VSS VDD VDD sky130_fd_sc_hd__fill_2
* cell instance sky130_fd_sc_hd__fill_2_371 r0 *1 0,0
Xsky130_fd_sc_hd__fill_2_371 VSS VDD VDD sky130_fd_sc_hd__fill_2
* cell instance sky130_fd_sc_hd__fill_2_372 r0 *1 0,0
Xsky130_fd_sc_hd__fill_2_372 VSS VDD VDD sky130_fd_sc_hd__fill_2
* cell instance sky130_fd_sc_hd__fill_2_373 r0 *1 0,0
Xsky130_fd_sc_hd__fill_2_373 VSS VDD VDD sky130_fd_sc_hd__fill_2
* cell instance sky130_fd_sc_hd__fill_2_374 r0 *1 0,0
Xsky130_fd_sc_hd__fill_2_374 VSS VDD VDD sky130_fd_sc_hd__fill_2
* cell instance sky130_fd_sc_hd__fill_2_375 r0 *1 0,0
Xsky130_fd_sc_hd__fill_2_375 VSS VDD VDD sky130_fd_sc_hd__fill_2
* cell instance sky130_fd_sc_hd__fill_2_376 r0 *1 0,0
Xsky130_fd_sc_hd__fill_2_376 VSS VDD VDD sky130_fd_sc_hd__fill_2
* cell instance sky130_fd_sc_hd__fill_2_377 r0 *1 0,0
Xsky130_fd_sc_hd__fill_2_377 VSS VDD VDD sky130_fd_sc_hd__fill_2
* cell instance sky130_fd_sc_hd__fill_2_378 r0 *1 0,0
Xsky130_fd_sc_hd__fill_2_378 VSS VDD VDD sky130_fd_sc_hd__fill_2
* cell instance sky130_fd_sc_hd__fill_2_379 r0 *1 0,0
Xsky130_fd_sc_hd__fill_2_379 VSS VDD VDD sky130_fd_sc_hd__fill_2
* cell instance sky130_fd_sc_hd__fill_2_380 r0 *1 0,0
Xsky130_fd_sc_hd__fill_2_380 VSS VDD VDD sky130_fd_sc_hd__fill_2
* cell instance sky130_fd_sc_hd__fill_2_381 r0 *1 0,0
Xsky130_fd_sc_hd__fill_2_381 VSS VDD VDD sky130_fd_sc_hd__fill_2
* cell instance sky130_fd_sc_hd__fill_2_382 r0 *1 0,0
Xsky130_fd_sc_hd__fill_2_382 VSS VDD VDD sky130_fd_sc_hd__fill_2
* cell instance sky130_fd_sc_hd__fill_2_383 r0 *1 0,0
Xsky130_fd_sc_hd__fill_2_383 VSS VDD VDD sky130_fd_sc_hd__fill_2
* cell instance sky130_fd_sc_hd__fill_2_384 r0 *1 0,0
Xsky130_fd_sc_hd__fill_2_384 VSS VDD VDD sky130_fd_sc_hd__fill_2
* cell instance sky130_fd_sc_hd__fill_2_385 r0 *1 0,0
Xsky130_fd_sc_hd__fill_2_385 VSS VDD VDD sky130_fd_sc_hd__fill_2
* cell instance sky130_fd_sc_hd__fill_2_386 r0 *1 0,0
Xsky130_fd_sc_hd__fill_2_386 VSS VDD VDD sky130_fd_sc_hd__fill_2
* cell instance sky130_fd_sc_hd__fill_2_387 r0 *1 0,0
Xsky130_fd_sc_hd__fill_2_387 VSS VDD VDD sky130_fd_sc_hd__fill_2
* cell instance sky130_fd_sc_hd__fill_2_388 r0 *1 0,0
Xsky130_fd_sc_hd__fill_2_388 VSS VDD VDD sky130_fd_sc_hd__fill_2
* cell instance sky130_fd_sc_hd__fill_2_389 r0 *1 0,0
Xsky130_fd_sc_hd__fill_2_389 VSS VDD VDD sky130_fd_sc_hd__fill_2
* cell instance sky130_fd_sc_hd__fill_2_390 r0 *1 0,0
Xsky130_fd_sc_hd__fill_2_390 VSS VDD VDD sky130_fd_sc_hd__fill_2
* cell instance sky130_fd_sc_hd__fill_2_391 r0 *1 0,0
Xsky130_fd_sc_hd__fill_2_391 VSS VDD VDD sky130_fd_sc_hd__fill_2
* cell instance sky130_fd_sc_hd__fill_2_392 r0 *1 0,0
Xsky130_fd_sc_hd__fill_2_392 VSS VDD VDD sky130_fd_sc_hd__fill_2
* cell instance sky130_fd_sc_hd__fill_2_393 r0 *1 0,0
Xsky130_fd_sc_hd__fill_2_393 VSS VDD VDD sky130_fd_sc_hd__fill_2
* cell instance sky130_fd_sc_hd__fill_2_394 r0 *1 0,0
Xsky130_fd_sc_hd__fill_2_394 VSS VDD VDD sky130_fd_sc_hd__fill_2
* cell instance sky130_fd_sc_hd__fill_2_395 r0 *1 0,0
Xsky130_fd_sc_hd__fill_2_395 VSS VDD VDD sky130_fd_sc_hd__fill_2
* cell instance sky130_fd_sc_hd__fill_2_396 r0 *1 0,0
Xsky130_fd_sc_hd__fill_2_396 VSS VDD VDD sky130_fd_sc_hd__fill_2
* cell instance sky130_fd_sc_hd__fill_2_397 r0 *1 0,0
Xsky130_fd_sc_hd__fill_2_397 VSS VDD VDD sky130_fd_sc_hd__fill_2
* cell instance sky130_fd_sc_hd__fill_2_398 r0 *1 0,0
Xsky130_fd_sc_hd__fill_2_398 VSS VDD VDD sky130_fd_sc_hd__fill_2
* cell instance sky130_fd_sc_hd__fill_2_399 r0 *1 0,0
Xsky130_fd_sc_hd__fill_2_399 VSS VDD VDD sky130_fd_sc_hd__fill_2
* cell instance sky130_fd_sc_hd__fill_2_400 r0 *1 0,0
Xsky130_fd_sc_hd__fill_2_400 VSS VDD VDD sky130_fd_sc_hd__fill_2
* cell instance sky130_fd_sc_hd__fill_2_401 r0 *1 0,0
Xsky130_fd_sc_hd__fill_2_401 VSS VDD VDD sky130_fd_sc_hd__fill_2
* cell instance sky130_fd_sc_hd__fill_2_402 r0 *1 0,0
Xsky130_fd_sc_hd__fill_2_402 VSS VDD VDD sky130_fd_sc_hd__fill_2
* cell instance sky130_fd_sc_hd__fill_2_403 r0 *1 0,0
Xsky130_fd_sc_hd__fill_2_403 VSS VDD VDD sky130_fd_sc_hd__fill_2
* cell instance sky130_fd_sc_hd__fill_2_404 r0 *1 0,0
Xsky130_fd_sc_hd__fill_2_404 VSS VDD VDD sky130_fd_sc_hd__fill_2
* cell instance sky130_fd_sc_hd__fill_2_405 r0 *1 0,0
Xsky130_fd_sc_hd__fill_2_405 VSS VDD VDD sky130_fd_sc_hd__fill_2
* cell instance sky130_fd_sc_hd__fill_2_406 r0 *1 0,0
Xsky130_fd_sc_hd__fill_2_406 VSS VDD VDD sky130_fd_sc_hd__fill_2
* cell instance sky130_fd_sc_hd__fill_2_407 r0 *1 0,0
Xsky130_fd_sc_hd__fill_2_407 VSS VDD VDD sky130_fd_sc_hd__fill_2
* cell instance sky130_fd_sc_hd__fill_2_408 r0 *1 0,0
Xsky130_fd_sc_hd__fill_2_408 VSS VDD VDD sky130_fd_sc_hd__fill_2
* cell instance sky130_fd_sc_hd__fill_2_409 r0 *1 0,0
Xsky130_fd_sc_hd__fill_2_409 VSS VDD VDD sky130_fd_sc_hd__fill_2
* cell instance sky130_fd_sc_hd__fill_2_410 r0 *1 0,0
Xsky130_fd_sc_hd__fill_2_410 VSS VDD VDD sky130_fd_sc_hd__fill_2
* cell instance sky130_fd_sc_hd__fill_2_411 r0 *1 0,0
Xsky130_fd_sc_hd__fill_2_411 VSS VDD VDD sky130_fd_sc_hd__fill_2
* cell instance sky130_fd_sc_hd__fill_2_412 r0 *1 0,0
Xsky130_fd_sc_hd__fill_2_412 VSS VDD VDD sky130_fd_sc_hd__fill_2
* cell instance sky130_fd_sc_hd__fill_2_413 r0 *1 0,0
Xsky130_fd_sc_hd__fill_2_413 VSS VDD VDD sky130_fd_sc_hd__fill_2
* cell instance sky130_fd_sc_hd__fill_2_414 r0 *1 0,0
Xsky130_fd_sc_hd__fill_2_414 VSS VDD VDD sky130_fd_sc_hd__fill_2
* cell instance sky130_fd_sc_hd__fill_2_415 r0 *1 0,0
Xsky130_fd_sc_hd__fill_2_415 VSS VDD VDD sky130_fd_sc_hd__fill_2
* cell instance sky130_fd_sc_hd__fill_2_416 r0 *1 0,0
Xsky130_fd_sc_hd__fill_2_416 VSS VDD VDD sky130_fd_sc_hd__fill_2
* cell instance sky130_fd_sc_hd__fill_2_417 r0 *1 0,0
Xsky130_fd_sc_hd__fill_2_417 VSS VDD VDD sky130_fd_sc_hd__fill_2
* cell instance sky130_fd_sc_hd__fill_2_418 r0 *1 0,0
Xsky130_fd_sc_hd__fill_2_418 VSS VDD VDD sky130_fd_sc_hd__fill_2
* cell instance sky130_fd_sc_hd__fill_2_419 r0 *1 0,0
Xsky130_fd_sc_hd__fill_2_419 VSS VDD VDD sky130_fd_sc_hd__fill_2
* cell instance sky130_fd_sc_hd__fill_2_420 r0 *1 0,0
Xsky130_fd_sc_hd__fill_2_420 VSS VDD VDD sky130_fd_sc_hd__fill_2
* cell instance sky130_fd_sc_hd__fill_2_421 r0 *1 0,0
Xsky130_fd_sc_hd__fill_2_421 VSS VDD VDD sky130_fd_sc_hd__fill_2
* cell instance sky130_fd_sc_hd__fill_2_422 r0 *1 0,0
Xsky130_fd_sc_hd__fill_2_422 VSS VDD VDD sky130_fd_sc_hd__fill_2
* cell instance sky130_fd_sc_hd__fill_2_423 r0 *1 0,0
Xsky130_fd_sc_hd__fill_2_423 VSS VDD VDD sky130_fd_sc_hd__fill_2
* cell instance sky130_fd_sc_hd__fill_2_424 r0 *1 0,0
Xsky130_fd_sc_hd__fill_2_424 VSS VDD VDD sky130_fd_sc_hd__fill_2
* cell instance sky130_fd_sc_hd__fill_2_425 r0 *1 0,0
Xsky130_fd_sc_hd__fill_2_425 VSS VDD VDD sky130_fd_sc_hd__fill_2
* cell instance sky130_fd_sc_hd__fill_4_0 r0 *1 0,0
Xsky130_fd_sc_hd__fill_4_0 VSS VDD VDD sky130_fd_sc_hd__fill_4
* cell instance sky130_fd_sc_hd__fill_4_1 r0 *1 0,0
Xsky130_fd_sc_hd__fill_4_1 VSS VDD VDD sky130_fd_sc_hd__fill_4
* cell instance sky130_fd_sc_hd__fill_4_2 r0 *1 0,0
Xsky130_fd_sc_hd__fill_4_2 VSS VDD VDD sky130_fd_sc_hd__fill_4
* cell instance sky130_fd_sc_hd__fill_4_3 r0 *1 0,0
Xsky130_fd_sc_hd__fill_4_3 VSS VDD VDD sky130_fd_sc_hd__fill_4
* cell instance sky130_fd_sc_hd__fill_4_4 r0 *1 0,0
Xsky130_fd_sc_hd__fill_4_4 VSS VDD VDD sky130_fd_sc_hd__fill_4
* cell instance sky130_fd_sc_hd__fill_4_5 r0 *1 0,0
Xsky130_fd_sc_hd__fill_4_5 VSS VDD VDD sky130_fd_sc_hd__fill_4
* cell instance sky130_fd_sc_hd__fill_4_6 r0 *1 0,0
Xsky130_fd_sc_hd__fill_4_6 VSS VDD VDD sky130_fd_sc_hd__fill_4
* cell instance sky130_fd_sc_hd__fill_4_7 r0 *1 0,0
Xsky130_fd_sc_hd__fill_4_7 VSS VDD VDD sky130_fd_sc_hd__fill_4
* cell instance sky130_fd_sc_hd__fill_4_8 r0 *1 0,0
Xsky130_fd_sc_hd__fill_4_8 VSS VDD VDD sky130_fd_sc_hd__fill_4
* cell instance sky130_fd_sc_hd__fill_4_9 r0 *1 0,0
Xsky130_fd_sc_hd__fill_4_9 VSS VDD VDD sky130_fd_sc_hd__fill_4
* cell instance sky130_fd_sc_hd__fill_4_10 r0 *1 0,0
Xsky130_fd_sc_hd__fill_4_10 VSS VDD VDD sky130_fd_sc_hd__fill_4
* cell instance sky130_fd_sc_hd__fill_4_11 r0 *1 0,0
Xsky130_fd_sc_hd__fill_4_11 VSS VDD VDD sky130_fd_sc_hd__fill_4
* cell instance sky130_fd_sc_hd__fill_4_12 r0 *1 0,0
Xsky130_fd_sc_hd__fill_4_12 VSS VDD VDD sky130_fd_sc_hd__fill_4
* cell instance sky130_fd_sc_hd__fill_4_13 r0 *1 0,0
Xsky130_fd_sc_hd__fill_4_13 VSS VDD VDD sky130_fd_sc_hd__fill_4
* cell instance sky130_fd_sc_hd__fill_4_14 r0 *1 0,0
Xsky130_fd_sc_hd__fill_4_14 VSS VDD VDD sky130_fd_sc_hd__fill_4
* cell instance sky130_fd_sc_hd__fill_4_15 r0 *1 0,0
Xsky130_fd_sc_hd__fill_4_15 VSS VDD VDD sky130_fd_sc_hd__fill_4
* cell instance sky130_fd_sc_hd__fill_4_16 r0 *1 0,0
Xsky130_fd_sc_hd__fill_4_16 VSS VDD VDD sky130_fd_sc_hd__fill_4
* cell instance sky130_fd_sc_hd__fill_4_17 r0 *1 0,0
Xsky130_fd_sc_hd__fill_4_17 VSS VDD VDD sky130_fd_sc_hd__fill_4
* cell instance sky130_fd_sc_hd__fill_4_18 r0 *1 0,0
Xsky130_fd_sc_hd__fill_4_18 VSS VDD VDD sky130_fd_sc_hd__fill_4
* cell instance sky130_fd_sc_hd__fill_4_19 r0 *1 0,0
Xsky130_fd_sc_hd__fill_4_19 VSS VDD VDD sky130_fd_sc_hd__fill_4
* cell instance sky130_fd_sc_hd__fill_4_20 r0 *1 0,0
Xsky130_fd_sc_hd__fill_4_20 VSS VDD VDD sky130_fd_sc_hd__fill_4
* cell instance sky130_fd_sc_hd__fill_4_21 r0 *1 0,0
Xsky130_fd_sc_hd__fill_4_21 VSS VDD VDD sky130_fd_sc_hd__fill_4
* cell instance sky130_fd_sc_hd__fill_4_22 r0 *1 0,0
Xsky130_fd_sc_hd__fill_4_22 VSS VDD VDD sky130_fd_sc_hd__fill_4
* cell instance sky130_fd_sc_hd__fill_4_23 r0 *1 0,0
Xsky130_fd_sc_hd__fill_4_23 VSS VDD VDD sky130_fd_sc_hd__fill_4
* cell instance sky130_fd_sc_hd__fill_4_24 r0 *1 0,0
Xsky130_fd_sc_hd__fill_4_24 VSS VDD VDD sky130_fd_sc_hd__fill_4
* cell instance sky130_fd_sc_hd__fill_4_25 r0 *1 0,0
Xsky130_fd_sc_hd__fill_4_25 VSS VDD VDD sky130_fd_sc_hd__fill_4
* cell instance sky130_fd_sc_hd__fill_4_26 r0 *1 0,0
Xsky130_fd_sc_hd__fill_4_26 VSS VDD VDD sky130_fd_sc_hd__fill_4
* cell instance sky130_fd_sc_hd__fill_4_27 r0 *1 0,0
Xsky130_fd_sc_hd__fill_4_27 VSS VDD VDD sky130_fd_sc_hd__fill_4
* cell instance sky130_fd_sc_hd__fill_4_28 r0 *1 0,0
Xsky130_fd_sc_hd__fill_4_28 VSS VDD VDD sky130_fd_sc_hd__fill_4
* cell instance sky130_fd_sc_hd__fill_4_29 r0 *1 0,0
Xsky130_fd_sc_hd__fill_4_29 VSS VDD VDD sky130_fd_sc_hd__fill_4
* cell instance sky130_fd_sc_hd__fill_4_30 r0 *1 0,0
Xsky130_fd_sc_hd__fill_4_30 VSS VDD VDD sky130_fd_sc_hd__fill_4
* cell instance sky130_fd_sc_hd__fill_4_31 r0 *1 0,0
Xsky130_fd_sc_hd__fill_4_31 VSS VDD VDD sky130_fd_sc_hd__fill_4
* cell instance sky130_fd_sc_hd__fill_4_32 r0 *1 0,0
Xsky130_fd_sc_hd__fill_4_32 VSS VDD VDD sky130_fd_sc_hd__fill_4
* cell instance sky130_fd_sc_hd__fill_4_33 r0 *1 0,0
Xsky130_fd_sc_hd__fill_4_33 VSS VDD VDD sky130_fd_sc_hd__fill_4
* cell instance sky130_fd_sc_hd__fill_4_34 r0 *1 0,0
Xsky130_fd_sc_hd__fill_4_34 VSS VDD VDD sky130_fd_sc_hd__fill_4
* cell instance sky130_fd_sc_hd__fill_4_35 r0 *1 0,0
Xsky130_fd_sc_hd__fill_4_35 VSS VDD VDD sky130_fd_sc_hd__fill_4
* cell instance sky130_fd_sc_hd__fill_4_36 r0 *1 0,0
Xsky130_fd_sc_hd__fill_4_36 VSS VDD VDD sky130_fd_sc_hd__fill_4
* cell instance sky130_fd_sc_hd__fill_4_37 r0 *1 0,0
Xsky130_fd_sc_hd__fill_4_37 VSS VDD VDD sky130_fd_sc_hd__fill_4
* cell instance sky130_fd_sc_hd__fill_4_38 r0 *1 0,0
Xsky130_fd_sc_hd__fill_4_38 VSS VDD VDD sky130_fd_sc_hd__fill_4
* cell instance sky130_fd_sc_hd__fill_4_39 r0 *1 0,0
Xsky130_fd_sc_hd__fill_4_39 VSS VDD VDD sky130_fd_sc_hd__fill_4
* cell instance sky130_fd_sc_hd__fill_4_40 r0 *1 0,0
Xsky130_fd_sc_hd__fill_4_40 VSS VDD VDD sky130_fd_sc_hd__fill_4
* cell instance sky130_fd_sc_hd__fill_4_41 r0 *1 0,0
Xsky130_fd_sc_hd__fill_4_41 VSS VDD VDD sky130_fd_sc_hd__fill_4
* cell instance sky130_fd_sc_hd__fill_4_42 r0 *1 0,0
Xsky130_fd_sc_hd__fill_4_42 VSS VDD VDD sky130_fd_sc_hd__fill_4
* cell instance sky130_fd_sc_hd__fill_4_43 r0 *1 0,0
Xsky130_fd_sc_hd__fill_4_43 VSS VDD VDD sky130_fd_sc_hd__fill_4
* cell instance sky130_fd_sc_hd__fill_4_44 r0 *1 0,0
Xsky130_fd_sc_hd__fill_4_44 VSS VDD VDD sky130_fd_sc_hd__fill_4
* cell instance sky130_fd_sc_hd__fill_4_45 r0 *1 0,0
Xsky130_fd_sc_hd__fill_4_45 VSS VDD VDD sky130_fd_sc_hd__fill_4
* cell instance sky130_fd_sc_hd__fill_4_46 r0 *1 0,0
Xsky130_fd_sc_hd__fill_4_46 VSS VDD VDD sky130_fd_sc_hd__fill_4
* cell instance sky130_fd_sc_hd__fill_4_47 r0 *1 0,0
Xsky130_fd_sc_hd__fill_4_47 VSS VDD VDD sky130_fd_sc_hd__fill_4
* cell instance sky130_fd_sc_hd__fill_4_48 r0 *1 0,0
Xsky130_fd_sc_hd__fill_4_48 VSS VDD VDD sky130_fd_sc_hd__fill_4
* cell instance sky130_fd_sc_hd__fill_4_49 r0 *1 0,0
Xsky130_fd_sc_hd__fill_4_49 VSS VDD VDD sky130_fd_sc_hd__fill_4
* cell instance sky130_fd_sc_hd__fill_4_50 r0 *1 0,0
Xsky130_fd_sc_hd__fill_4_50 VSS VDD VDD sky130_fd_sc_hd__fill_4
* cell instance sky130_fd_sc_hd__fill_4_51 r0 *1 0,0
Xsky130_fd_sc_hd__fill_4_51 VSS VDD VDD sky130_fd_sc_hd__fill_4
* cell instance sky130_fd_sc_hd__fill_4_52 r0 *1 0,0
Xsky130_fd_sc_hd__fill_4_52 VSS VDD VDD sky130_fd_sc_hd__fill_4
* cell instance sky130_fd_sc_hd__fill_4_53 r0 *1 0,0
Xsky130_fd_sc_hd__fill_4_53 VSS VDD VDD sky130_fd_sc_hd__fill_4
* cell instance sky130_fd_sc_hd__fill_4_54 r0 *1 0,0
Xsky130_fd_sc_hd__fill_4_54 VSS VDD VDD sky130_fd_sc_hd__fill_4
* cell instance sky130_fd_sc_hd__fill_4_55 r0 *1 0,0
Xsky130_fd_sc_hd__fill_4_55 VSS VDD VDD sky130_fd_sc_hd__fill_4
* cell instance sky130_fd_sc_hd__fill_4_56 r0 *1 0,0
Xsky130_fd_sc_hd__fill_4_56 VSS VDD VDD sky130_fd_sc_hd__fill_4
* cell instance sky130_fd_sc_hd__fill_4_57 r0 *1 0,0
Xsky130_fd_sc_hd__fill_4_57 VSS VDD VDD sky130_fd_sc_hd__fill_4
* cell instance sky130_fd_sc_hd__fill_4_58 r0 *1 0,0
Xsky130_fd_sc_hd__fill_4_58 VSS VDD VDD sky130_fd_sc_hd__fill_4
* cell instance sky130_fd_sc_hd__fill_4_59 r0 *1 0,0
Xsky130_fd_sc_hd__fill_4_59 VSS VDD VDD sky130_fd_sc_hd__fill_4
* cell instance sky130_fd_sc_hd__fill_4_60 r0 *1 0,0
Xsky130_fd_sc_hd__fill_4_60 VSS VDD VDD sky130_fd_sc_hd__fill_4
* cell instance sky130_fd_sc_hd__fill_4_61 r0 *1 0,0
Xsky130_fd_sc_hd__fill_4_61 VSS VDD VDD sky130_fd_sc_hd__fill_4
* cell instance sky130_fd_sc_hd__fill_4_62 r0 *1 0,0
Xsky130_fd_sc_hd__fill_4_62 VSS VDD VDD sky130_fd_sc_hd__fill_4
* cell instance sky130_fd_sc_hd__fill_4_63 r0 *1 0,0
Xsky130_fd_sc_hd__fill_4_63 VSS VDD VDD sky130_fd_sc_hd__fill_4
* cell instance sky130_fd_sc_hd__fill_4_64 r0 *1 0,0
Xsky130_fd_sc_hd__fill_4_64 VSS VDD VDD sky130_fd_sc_hd__fill_4
* cell instance sky130_fd_sc_hd__fill_4_65 r0 *1 0,0
Xsky130_fd_sc_hd__fill_4_65 VSS VDD VDD sky130_fd_sc_hd__fill_4
* cell instance sky130_fd_sc_hd__fill_4_66 r0 *1 0,0
Xsky130_fd_sc_hd__fill_4_66 VSS VDD VDD sky130_fd_sc_hd__fill_4
* cell instance sky130_fd_sc_hd__fill_4_67 r0 *1 0,0
Xsky130_fd_sc_hd__fill_4_67 VSS VDD VDD sky130_fd_sc_hd__fill_4
* cell instance sky130_fd_sc_hd__fill_4_68 r0 *1 0,0
Xsky130_fd_sc_hd__fill_4_68 VSS VDD VDD sky130_fd_sc_hd__fill_4
* cell instance sky130_fd_sc_hd__fill_4_69 r0 *1 0,0
Xsky130_fd_sc_hd__fill_4_69 VSS VDD VDD sky130_fd_sc_hd__fill_4
* cell instance sky130_fd_sc_hd__fill_4_70 r0 *1 0,0
Xsky130_fd_sc_hd__fill_4_70 VSS VDD VDD sky130_fd_sc_hd__fill_4
* cell instance sky130_fd_sc_hd__fill_4_71 r0 *1 0,0
Xsky130_fd_sc_hd__fill_4_71 VSS VDD VDD sky130_fd_sc_hd__fill_4
* cell instance sky130_fd_sc_hd__fill_4_72 r0 *1 0,0
Xsky130_fd_sc_hd__fill_4_72 VSS VDD VDD sky130_fd_sc_hd__fill_4
* cell instance sky130_fd_sc_hd__fill_4_73 r0 *1 0,0
Xsky130_fd_sc_hd__fill_4_73 VSS VDD VDD sky130_fd_sc_hd__fill_4
* cell instance sky130_fd_sc_hd__fill_4_74 r0 *1 0,0
Xsky130_fd_sc_hd__fill_4_74 VSS VDD VDD sky130_fd_sc_hd__fill_4
* cell instance sky130_fd_sc_hd__fill_4_75 r0 *1 0,0
Xsky130_fd_sc_hd__fill_4_75 VSS VDD VDD sky130_fd_sc_hd__fill_4
* cell instance sky130_fd_sc_hd__fill_4_76 r0 *1 0,0
Xsky130_fd_sc_hd__fill_4_76 VSS VDD VDD sky130_fd_sc_hd__fill_4
* cell instance sky130_fd_sc_hd__fill_4_77 r0 *1 0,0
Xsky130_fd_sc_hd__fill_4_77 VSS VDD VDD sky130_fd_sc_hd__fill_4
* cell instance sky130_fd_sc_hd__fill_4_78 r0 *1 0,0
Xsky130_fd_sc_hd__fill_4_78 VSS VDD VDD sky130_fd_sc_hd__fill_4
* cell instance sky130_fd_sc_hd__fill_4_79 r0 *1 0,0
Xsky130_fd_sc_hd__fill_4_79 VSS VDD VDD sky130_fd_sc_hd__fill_4
* cell instance sky130_fd_sc_hd__fill_4_80 r0 *1 0,0
Xsky130_fd_sc_hd__fill_4_80 VSS VDD VDD sky130_fd_sc_hd__fill_4
* cell instance sky130_fd_sc_hd__fill_4_81 r0 *1 0,0
Xsky130_fd_sc_hd__fill_4_81 VSS VDD VDD sky130_fd_sc_hd__fill_4
* cell instance sky130_fd_sc_hd__fill_4_82 r0 *1 0,0
Xsky130_fd_sc_hd__fill_4_82 VSS VDD VDD sky130_fd_sc_hd__fill_4
* cell instance sky130_fd_sc_hd__fill_4_83 r0 *1 0,0
Xsky130_fd_sc_hd__fill_4_83 VSS VDD VDD sky130_fd_sc_hd__fill_4
* cell instance sky130_fd_sc_hd__fill_4_84 r0 *1 0,0
Xsky130_fd_sc_hd__fill_4_84 VSS VDD VDD sky130_fd_sc_hd__fill_4
* cell instance sky130_fd_sc_hd__fill_4_85 r0 *1 0,0
Xsky130_fd_sc_hd__fill_4_85 VSS VDD VDD sky130_fd_sc_hd__fill_4
* cell instance sky130_fd_sc_hd__fill_4_86 r0 *1 0,0
Xsky130_fd_sc_hd__fill_4_86 VSS VDD VDD sky130_fd_sc_hd__fill_4
* cell instance sky130_fd_sc_hd__fill_4_87 r0 *1 0,0
Xsky130_fd_sc_hd__fill_4_87 VSS VDD VDD sky130_fd_sc_hd__fill_4
* cell instance sky130_fd_sc_hd__fill_4_88 r0 *1 0,0
Xsky130_fd_sc_hd__fill_4_88 VSS VDD VDD sky130_fd_sc_hd__fill_4
* cell instance sky130_fd_sc_hd__fill_4_89 r0 *1 0,0
Xsky130_fd_sc_hd__fill_4_89 VSS VDD VDD sky130_fd_sc_hd__fill_4
* cell instance sky130_fd_sc_hd__fill_4_90 r0 *1 0,0
Xsky130_fd_sc_hd__fill_4_90 VSS VDD VDD sky130_fd_sc_hd__fill_4
* cell instance sky130_fd_sc_hd__fill_4_91 r0 *1 0,0
Xsky130_fd_sc_hd__fill_4_91 VSS VDD VDD sky130_fd_sc_hd__fill_4
* cell instance sky130_fd_sc_hd__fill_4_92 r0 *1 0,0
Xsky130_fd_sc_hd__fill_4_92 VSS VDD VDD sky130_fd_sc_hd__fill_4
* cell instance sky130_fd_sc_hd__fill_4_93 r0 *1 0,0
Xsky130_fd_sc_hd__fill_4_93 VSS VDD VDD sky130_fd_sc_hd__fill_4
* cell instance sky130_fd_sc_hd__fill_4_94 r0 *1 0,0
Xsky130_fd_sc_hd__fill_4_94 VSS VDD VDD sky130_fd_sc_hd__fill_4
* cell instance sky130_fd_sc_hd__fill_4_95 r0 *1 0,0
Xsky130_fd_sc_hd__fill_4_95 VSS VDD VDD sky130_fd_sc_hd__fill_4
* cell instance sky130_fd_sc_hd__fill_4_96 r0 *1 0,0
Xsky130_fd_sc_hd__fill_4_96 VSS VDD VDD sky130_fd_sc_hd__fill_4
* cell instance sky130_fd_sc_hd__fill_4_97 r0 *1 0,0
Xsky130_fd_sc_hd__fill_4_97 VSS VDD VDD sky130_fd_sc_hd__fill_4
* cell instance sky130_fd_sc_hd__fill_4_98 r0 *1 0,0
Xsky130_fd_sc_hd__fill_4_98 VSS VDD VDD sky130_fd_sc_hd__fill_4
* cell instance sky130_fd_sc_hd__fill_4_99 r0 *1 0,0
Xsky130_fd_sc_hd__fill_4_99 VSS VDD VDD sky130_fd_sc_hd__fill_4
* cell instance sky130_fd_sc_hd__fill_4_100 r0 *1 0,0
Xsky130_fd_sc_hd__fill_4_100 VSS VDD VDD sky130_fd_sc_hd__fill_4
* cell instance sky130_fd_sc_hd__fill_4_101 r0 *1 0,0
Xsky130_fd_sc_hd__fill_4_101 VSS VDD VDD sky130_fd_sc_hd__fill_4
* cell instance sky130_fd_sc_hd__fill_4_102 r0 *1 0,0
Xsky130_fd_sc_hd__fill_4_102 VSS VDD VDD sky130_fd_sc_hd__fill_4
* cell instance sky130_fd_sc_hd__fill_4_103 r0 *1 0,0
Xsky130_fd_sc_hd__fill_4_103 VSS VDD VDD sky130_fd_sc_hd__fill_4
* cell instance sky130_fd_sc_hd__fill_4_104 r0 *1 0,0
Xsky130_fd_sc_hd__fill_4_104 VSS VDD VDD sky130_fd_sc_hd__fill_4
* cell instance sky130_fd_sc_hd__fill_4_105 r0 *1 0,0
Xsky130_fd_sc_hd__fill_4_105 VSS VDD VDD sky130_fd_sc_hd__fill_4
* cell instance sky130_fd_sc_hd__fill_4_106 r0 *1 0,0
Xsky130_fd_sc_hd__fill_4_106 VSS VDD VDD sky130_fd_sc_hd__fill_4
* cell instance sky130_fd_sc_hd__fill_4_107 r0 *1 0,0
Xsky130_fd_sc_hd__fill_4_107 VSS VDD VDD sky130_fd_sc_hd__fill_4
* cell instance sky130_fd_sc_hd__fill_4_108 r0 *1 0,0
Xsky130_fd_sc_hd__fill_4_108 VSS VDD VDD sky130_fd_sc_hd__fill_4
* cell instance sky130_fd_sc_hd__fill_4_109 r0 *1 0,0
Xsky130_fd_sc_hd__fill_4_109 VSS VDD VDD sky130_fd_sc_hd__fill_4
* cell instance sky130_fd_sc_hd__fill_4_110 r0 *1 0,0
Xsky130_fd_sc_hd__fill_4_110 VSS VDD VDD sky130_fd_sc_hd__fill_4
* cell instance sky130_fd_sc_hd__fill_4_111 r0 *1 0,0
Xsky130_fd_sc_hd__fill_4_111 VSS VDD VDD sky130_fd_sc_hd__fill_4
* cell instance sky130_fd_sc_hd__fill_4_112 r0 *1 0,0
Xsky130_fd_sc_hd__fill_4_112 VSS VDD VDD sky130_fd_sc_hd__fill_4
* cell instance sky130_fd_sc_hd__fill_4_113 r0 *1 0,0
Xsky130_fd_sc_hd__fill_4_113 VSS VDD VDD sky130_fd_sc_hd__fill_4
* cell instance sky130_fd_sc_hd__fill_4_114 r0 *1 0,0
Xsky130_fd_sc_hd__fill_4_114 VSS VDD VDD sky130_fd_sc_hd__fill_4
* cell instance sky130_fd_sc_hd__fill_4_115 r0 *1 0,0
Xsky130_fd_sc_hd__fill_4_115 VSS VDD VDD sky130_fd_sc_hd__fill_4
* cell instance sky130_fd_sc_hd__fill_4_116 r0 *1 0,0
Xsky130_fd_sc_hd__fill_4_116 VSS VDD VDD sky130_fd_sc_hd__fill_4
* cell instance sky130_fd_sc_hd__fill_4_117 r0 *1 0,0
Xsky130_fd_sc_hd__fill_4_117 VSS VDD VDD sky130_fd_sc_hd__fill_4
* cell instance sky130_fd_sc_hd__fill_4_118 r0 *1 0,0
Xsky130_fd_sc_hd__fill_4_118 VSS VDD VDD sky130_fd_sc_hd__fill_4
* cell instance sky130_fd_sc_hd__fill_4_119 r0 *1 0,0
Xsky130_fd_sc_hd__fill_4_119 VSS VDD VDD sky130_fd_sc_hd__fill_4
* cell instance sky130_fd_sc_hd__fill_4_120 r0 *1 0,0
Xsky130_fd_sc_hd__fill_4_120 VSS VDD VDD sky130_fd_sc_hd__fill_4
* cell instance sky130_fd_sc_hd__fill_4_121 r0 *1 0,0
Xsky130_fd_sc_hd__fill_4_121 VSS VDD VDD sky130_fd_sc_hd__fill_4
* cell instance sky130_fd_sc_hd__fill_4_122 r0 *1 0,0
Xsky130_fd_sc_hd__fill_4_122 VSS VDD VDD sky130_fd_sc_hd__fill_4
* cell instance sky130_fd_sc_hd__fill_4_123 r0 *1 0,0
Xsky130_fd_sc_hd__fill_4_123 VSS VDD VDD sky130_fd_sc_hd__fill_4
* cell instance sky130_fd_sc_hd__fill_4_124 r0 *1 0,0
Xsky130_fd_sc_hd__fill_4_124 VSS VDD VDD sky130_fd_sc_hd__fill_4
* cell instance sky130_fd_sc_hd__fill_4_125 r0 *1 0,0
Xsky130_fd_sc_hd__fill_4_125 VSS VDD VDD sky130_fd_sc_hd__fill_4
* cell instance sky130_fd_sc_hd__fill_4_126 r0 *1 0,0
Xsky130_fd_sc_hd__fill_4_126 VSS VDD VDD sky130_fd_sc_hd__fill_4
* cell instance sky130_fd_sc_hd__fill_4_127 r0 *1 0,0
Xsky130_fd_sc_hd__fill_4_127 VSS VDD VDD sky130_fd_sc_hd__fill_4
* cell instance sky130_fd_sc_hd__fill_4_128 r0 *1 0,0
Xsky130_fd_sc_hd__fill_4_128 VSS VDD VDD sky130_fd_sc_hd__fill_4
* cell instance sky130_fd_sc_hd__fill_4_129 r0 *1 0,0
Xsky130_fd_sc_hd__fill_4_129 VSS VDD VDD sky130_fd_sc_hd__fill_4
* cell instance sky130_fd_sc_hd__fill_4_130 r0 *1 0,0
Xsky130_fd_sc_hd__fill_4_130 VSS VDD VDD sky130_fd_sc_hd__fill_4
* cell instance sky130_fd_sc_hd__fill_4_131 r0 *1 0,0
Xsky130_fd_sc_hd__fill_4_131 VSS VDD VDD sky130_fd_sc_hd__fill_4
* cell instance sky130_fd_sc_hd__fill_4_132 r0 *1 0,0
Xsky130_fd_sc_hd__fill_4_132 VSS VDD VDD sky130_fd_sc_hd__fill_4
* cell instance sky130_fd_sc_hd__fill_4_133 r0 *1 0,0
Xsky130_fd_sc_hd__fill_4_133 VSS VDD VDD sky130_fd_sc_hd__fill_4
* cell instance sky130_fd_sc_hd__fill_4_134 r0 *1 0,0
Xsky130_fd_sc_hd__fill_4_134 VSS VDD VDD sky130_fd_sc_hd__fill_4
* cell instance sky130_fd_sc_hd__fill_4_135 r0 *1 0,0
Xsky130_fd_sc_hd__fill_4_135 VSS VDD VDD sky130_fd_sc_hd__fill_4
* cell instance sky130_fd_sc_hd__fill_4_136 r0 *1 0,0
Xsky130_fd_sc_hd__fill_4_136 VSS VDD VDD sky130_fd_sc_hd__fill_4
* cell instance sky130_fd_sc_hd__fill_4_137 r0 *1 0,0
Xsky130_fd_sc_hd__fill_4_137 VSS VDD VDD sky130_fd_sc_hd__fill_4
* cell instance sky130_fd_sc_hd__fill_4_138 r0 *1 0,0
Xsky130_fd_sc_hd__fill_4_138 VSS VDD VDD sky130_fd_sc_hd__fill_4
* cell instance sky130_fd_sc_hd__fill_4_139 r0 *1 0,0
Xsky130_fd_sc_hd__fill_4_139 VSS VDD VDD sky130_fd_sc_hd__fill_4
* cell instance sky130_fd_sc_hd__fill_4_140 r0 *1 0,0
Xsky130_fd_sc_hd__fill_4_140 VSS VDD VDD sky130_fd_sc_hd__fill_4
* cell instance sky130_fd_sc_hd__fill_4_141 r0 *1 0,0
Xsky130_fd_sc_hd__fill_4_141 VSS VDD VDD sky130_fd_sc_hd__fill_4
* cell instance sky130_fd_sc_hd__fill_4_142 r0 *1 0,0
Xsky130_fd_sc_hd__fill_4_142 VSS VDD VDD sky130_fd_sc_hd__fill_4
* cell instance sky130_fd_sc_hd__fill_4_143 r0 *1 0,0
Xsky130_fd_sc_hd__fill_4_143 VSS VDD VDD sky130_fd_sc_hd__fill_4
* cell instance sky130_fd_sc_hd__fill_4_144 r0 *1 0,0
Xsky130_fd_sc_hd__fill_4_144 VSS VDD VDD sky130_fd_sc_hd__fill_4
* cell instance sky130_fd_sc_hd__fill_4_145 r0 *1 0,0
Xsky130_fd_sc_hd__fill_4_145 VSS VDD VDD sky130_fd_sc_hd__fill_4
* cell instance sky130_fd_sc_hd__fill_4_146 r0 *1 0,0
Xsky130_fd_sc_hd__fill_4_146 VSS VDD VDD sky130_fd_sc_hd__fill_4
* cell instance sky130_fd_sc_hd__fill_4_147 r0 *1 0,0
Xsky130_fd_sc_hd__fill_4_147 VSS VDD VDD sky130_fd_sc_hd__fill_4
* cell instance sky130_fd_sc_hd__fill_4_148 r0 *1 0,0
Xsky130_fd_sc_hd__fill_4_148 VSS VDD VDD sky130_fd_sc_hd__fill_4
* cell instance sky130_fd_sc_hd__fill_4_149 r0 *1 0,0
Xsky130_fd_sc_hd__fill_4_149 VSS VDD VDD sky130_fd_sc_hd__fill_4
* cell instance sky130_fd_sc_hd__fill_4_150 r0 *1 0,0
Xsky130_fd_sc_hd__fill_4_150 VSS VDD VDD sky130_fd_sc_hd__fill_4
* cell instance sky130_fd_sc_hd__fill_4_151 r0 *1 0,0
Xsky130_fd_sc_hd__fill_4_151 VSS VDD VDD sky130_fd_sc_hd__fill_4
* cell instance sky130_fd_sc_hd__fill_4_152 r0 *1 0,0
Xsky130_fd_sc_hd__fill_4_152 VSS VDD VDD sky130_fd_sc_hd__fill_4
* cell instance sky130_fd_sc_hd__fill_4_153 r0 *1 0,0
Xsky130_fd_sc_hd__fill_4_153 VSS VDD VDD sky130_fd_sc_hd__fill_4
* cell instance sky130_fd_sc_hd__fill_4_154 r0 *1 0,0
Xsky130_fd_sc_hd__fill_4_154 VSS VDD VDD sky130_fd_sc_hd__fill_4
* cell instance sky130_fd_sc_hd__fill_4_155 r0 *1 0,0
Xsky130_fd_sc_hd__fill_4_155 VSS VDD VDD sky130_fd_sc_hd__fill_4
* cell instance sky130_fd_sc_hd__fill_4_156 r0 *1 0,0
Xsky130_fd_sc_hd__fill_4_156 VSS VDD VDD sky130_fd_sc_hd__fill_4
* cell instance sky130_fd_sc_hd__fill_4_157 r0 *1 0,0
Xsky130_fd_sc_hd__fill_4_157 VSS VDD VDD sky130_fd_sc_hd__fill_4
* cell instance sky130_fd_sc_hd__fill_4_158 r0 *1 0,0
Xsky130_fd_sc_hd__fill_4_158 VSS VDD VDD sky130_fd_sc_hd__fill_4
* cell instance sky130_fd_sc_hd__fill_4_159 r0 *1 0,0
Xsky130_fd_sc_hd__fill_4_159 VSS VDD VDD sky130_fd_sc_hd__fill_4
* cell instance sky130_fd_sc_hd__fill_4_160 r0 *1 0,0
Xsky130_fd_sc_hd__fill_4_160 VSS VDD VDD sky130_fd_sc_hd__fill_4
* cell instance sky130_fd_sc_hd__fill_4_161 r0 *1 0,0
Xsky130_fd_sc_hd__fill_4_161 VSS VDD VDD sky130_fd_sc_hd__fill_4
* cell instance sky130_fd_sc_hd__fill_4_162 r0 *1 0,0
Xsky130_fd_sc_hd__fill_4_162 VSS VDD VDD sky130_fd_sc_hd__fill_4
* cell instance sky130_fd_sc_hd__fill_4_163 r0 *1 0,0
Xsky130_fd_sc_hd__fill_4_163 VSS VDD VDD sky130_fd_sc_hd__fill_4
* cell instance sky130_fd_sc_hd__fill_4_164 r0 *1 0,0
Xsky130_fd_sc_hd__fill_4_164 VSS VDD VDD sky130_fd_sc_hd__fill_4
* cell instance sky130_fd_sc_hd__fill_4_165 r0 *1 0,0
Xsky130_fd_sc_hd__fill_4_165 VSS VDD VDD sky130_fd_sc_hd__fill_4
* cell instance sky130_fd_sc_hd__fill_4_166 r0 *1 0,0
Xsky130_fd_sc_hd__fill_4_166 VSS VDD VDD sky130_fd_sc_hd__fill_4
* cell instance sky130_fd_sc_hd__fill_4_167 r0 *1 0,0
Xsky130_fd_sc_hd__fill_4_167 VSS VDD VDD sky130_fd_sc_hd__fill_4
* cell instance sky130_fd_sc_hd__fill_4_168 r0 *1 0,0
Xsky130_fd_sc_hd__fill_4_168 VSS VDD VDD sky130_fd_sc_hd__fill_4
* cell instance sky130_fd_sc_hd__fill_4_169 r0 *1 0,0
Xsky130_fd_sc_hd__fill_4_169 VSS VDD VDD sky130_fd_sc_hd__fill_4
* cell instance sky130_fd_sc_hd__fill_4_170 r0 *1 0,0
Xsky130_fd_sc_hd__fill_4_170 VSS VDD VDD sky130_fd_sc_hd__fill_4
* cell instance sky130_fd_sc_hd__fill_4_171 r0 *1 0,0
Xsky130_fd_sc_hd__fill_4_171 VSS VDD VDD sky130_fd_sc_hd__fill_4
* cell instance sky130_fd_sc_hd__fill_4_172 r0 *1 0,0
Xsky130_fd_sc_hd__fill_4_172 VSS VDD VDD sky130_fd_sc_hd__fill_4
* cell instance sky130_fd_sc_hd__fill_4_173 r0 *1 0,0
Xsky130_fd_sc_hd__fill_4_173 VSS VDD VDD sky130_fd_sc_hd__fill_4
* cell instance sky130_fd_sc_hd__fill_4_174 r0 *1 0,0
Xsky130_fd_sc_hd__fill_4_174 VSS VDD VDD sky130_fd_sc_hd__fill_4
* cell instance sky130_fd_sc_hd__fill_4_175 r0 *1 0,0
Xsky130_fd_sc_hd__fill_4_175 VSS VDD VDD sky130_fd_sc_hd__fill_4
* cell instance sky130_fd_sc_hd__fill_4_176 r0 *1 0,0
Xsky130_fd_sc_hd__fill_4_176 VSS VDD VDD sky130_fd_sc_hd__fill_4
* cell instance sky130_fd_sc_hd__fill_4_177 r0 *1 0,0
Xsky130_fd_sc_hd__fill_4_177 VSS VDD VDD sky130_fd_sc_hd__fill_4
* cell instance sky130_fd_sc_hd__fill_4_178 r0 *1 0,0
Xsky130_fd_sc_hd__fill_4_178 VSS VDD VDD sky130_fd_sc_hd__fill_4
* cell instance sky130_fd_sc_hd__fill_4_179 r0 *1 0,0
Xsky130_fd_sc_hd__fill_4_179 VSS VDD VDD sky130_fd_sc_hd__fill_4
* cell instance sky130_fd_sc_hd__fill_4_180 r0 *1 0,0
Xsky130_fd_sc_hd__fill_4_180 VSS VDD VDD sky130_fd_sc_hd__fill_4
* cell instance sky130_fd_sc_hd__fill_4_181 r0 *1 0,0
Xsky130_fd_sc_hd__fill_4_181 VSS VDD VDD sky130_fd_sc_hd__fill_4
* cell instance sky130_fd_sc_hd__fill_4_182 r0 *1 0,0
Xsky130_fd_sc_hd__fill_4_182 VSS VDD VDD sky130_fd_sc_hd__fill_4
* cell instance sky130_fd_sc_hd__fill_4_183 r0 *1 0,0
Xsky130_fd_sc_hd__fill_4_183 VSS VDD VDD sky130_fd_sc_hd__fill_4
* cell instance sky130_fd_sc_hd__fill_4_184 r0 *1 0,0
Xsky130_fd_sc_hd__fill_4_184 VSS VDD VDD sky130_fd_sc_hd__fill_4
* cell instance sky130_fd_sc_hd__fill_4_185 r0 *1 0,0
Xsky130_fd_sc_hd__fill_4_185 VSS VDD VDD sky130_fd_sc_hd__fill_4
* cell instance sky130_fd_sc_hd__fill_4_186 r0 *1 0,0
Xsky130_fd_sc_hd__fill_4_186 VSS VDD VDD sky130_fd_sc_hd__fill_4
* cell instance sky130_fd_sc_hd__fill_4_187 r0 *1 0,0
Xsky130_fd_sc_hd__fill_4_187 VSS VDD VDD sky130_fd_sc_hd__fill_4
* cell instance sky130_fd_sc_hd__fill_4_188 r0 *1 0,0
Xsky130_fd_sc_hd__fill_4_188 VSS VDD VDD sky130_fd_sc_hd__fill_4
* cell instance sky130_fd_sc_hd__fill_4_189 r0 *1 0,0
Xsky130_fd_sc_hd__fill_4_189 VSS VDD VDD sky130_fd_sc_hd__fill_4
* cell instance sky130_fd_sc_hd__fill_4_190 r0 *1 0,0
Xsky130_fd_sc_hd__fill_4_190 VSS VDD VDD sky130_fd_sc_hd__fill_4
* cell instance sky130_fd_sc_hd__fill_4_191 r0 *1 0,0
Xsky130_fd_sc_hd__fill_4_191 VSS VDD VDD sky130_fd_sc_hd__fill_4
* cell instance sky130_fd_sc_hd__fill_4_192 r0 *1 0,0
Xsky130_fd_sc_hd__fill_4_192 VSS VDD VDD sky130_fd_sc_hd__fill_4
* cell instance sky130_fd_sc_hd__fill_4_193 r0 *1 0,0
Xsky130_fd_sc_hd__fill_4_193 VSS VDD VDD sky130_fd_sc_hd__fill_4
* cell instance sky130_fd_sc_hd__fill_4_194 r0 *1 0,0
Xsky130_fd_sc_hd__fill_4_194 VSS VDD VDD sky130_fd_sc_hd__fill_4
* cell instance sky130_fd_sc_hd__fill_4_195 r0 *1 0,0
Xsky130_fd_sc_hd__fill_4_195 VSS VDD VDD sky130_fd_sc_hd__fill_4
* cell instance sky130_fd_sc_hd__fill_4_196 r0 *1 0,0
Xsky130_fd_sc_hd__fill_4_196 VSS VDD VDD sky130_fd_sc_hd__fill_4
* cell instance sky130_fd_sc_hd__fill_4_197 r0 *1 0,0
Xsky130_fd_sc_hd__fill_4_197 VSS VDD VDD sky130_fd_sc_hd__fill_4
* cell instance sky130_fd_sc_hd__fill_4_198 r0 *1 0,0
Xsky130_fd_sc_hd__fill_4_198 VSS VDD VDD sky130_fd_sc_hd__fill_4
* cell instance sky130_fd_sc_hd__fill_4_199 r0 *1 0,0
Xsky130_fd_sc_hd__fill_4_199 VSS VDD VDD sky130_fd_sc_hd__fill_4
* cell instance sky130_fd_sc_hd__fill_4_200 r0 *1 0,0
Xsky130_fd_sc_hd__fill_4_200 VSS VDD VDD sky130_fd_sc_hd__fill_4
* cell instance sky130_fd_sc_hd__fill_4_201 r0 *1 0,0
Xsky130_fd_sc_hd__fill_4_201 VSS VDD VDD sky130_fd_sc_hd__fill_4
* cell instance sky130_fd_sc_hd__fill_4_202 r0 *1 0,0
Xsky130_fd_sc_hd__fill_4_202 VSS VDD VDD sky130_fd_sc_hd__fill_4
* cell instance sky130_fd_sc_hd__fill_4_203 r0 *1 0,0
Xsky130_fd_sc_hd__fill_4_203 VSS VDD VDD sky130_fd_sc_hd__fill_4
* cell instance sky130_fd_sc_hd__fill_4_204 r0 *1 0,0
Xsky130_fd_sc_hd__fill_4_204 VSS VDD VDD sky130_fd_sc_hd__fill_4
* cell instance sky130_fd_sc_hd__fill_4_205 r0 *1 0,0
Xsky130_fd_sc_hd__fill_4_205 VSS VDD VDD sky130_fd_sc_hd__fill_4
* cell instance sky130_fd_sc_hd__fill_4_206 r0 *1 0,0
Xsky130_fd_sc_hd__fill_4_206 VSS VDD VDD sky130_fd_sc_hd__fill_4
* cell instance sky130_fd_sc_hd__fill_4_207 r0 *1 0,0
Xsky130_fd_sc_hd__fill_4_207 VSS VDD VDD sky130_fd_sc_hd__fill_4
* cell instance sky130_fd_sc_hd__fill_4_208 r0 *1 0,0
Xsky130_fd_sc_hd__fill_4_208 VSS VDD VDD sky130_fd_sc_hd__fill_4
* cell instance sky130_fd_sc_hd__fill_4_209 r0 *1 0,0
Xsky130_fd_sc_hd__fill_4_209 VSS VDD VDD sky130_fd_sc_hd__fill_4
* cell instance sky130_fd_sc_hd__fill_4_210 r0 *1 0,0
Xsky130_fd_sc_hd__fill_4_210 VSS VDD VDD sky130_fd_sc_hd__fill_4
* cell instance sky130_fd_sc_hd__fill_4_211 r0 *1 0,0
Xsky130_fd_sc_hd__fill_4_211 VSS VDD VDD sky130_fd_sc_hd__fill_4
* cell instance sky130_fd_sc_hd__fill_4_212 r0 *1 0,0
Xsky130_fd_sc_hd__fill_4_212 VSS VDD VDD sky130_fd_sc_hd__fill_4
* cell instance sky130_fd_sc_hd__fill_4_213 r0 *1 0,0
Xsky130_fd_sc_hd__fill_4_213 VSS VDD VDD sky130_fd_sc_hd__fill_4
* cell instance sky130_fd_sc_hd__fill_4_214 r0 *1 0,0
Xsky130_fd_sc_hd__fill_4_214 VSS VDD VDD sky130_fd_sc_hd__fill_4
* cell instance sky130_fd_sc_hd__fill_4_215 r0 *1 0,0
Xsky130_fd_sc_hd__fill_4_215 VSS VDD VDD sky130_fd_sc_hd__fill_4
* cell instance sky130_fd_sc_hd__fill_4_216 r0 *1 0,0
Xsky130_fd_sc_hd__fill_4_216 VSS VDD VDD sky130_fd_sc_hd__fill_4
* cell instance sky130_fd_sc_hd__fill_4_217 r0 *1 0,0
Xsky130_fd_sc_hd__fill_4_217 VSS VDD VDD sky130_fd_sc_hd__fill_4
* cell instance sky130_fd_sc_hd__fill_4_218 r0 *1 0,0
Xsky130_fd_sc_hd__fill_4_218 VSS VDD VDD sky130_fd_sc_hd__fill_4
* cell instance sky130_fd_sc_hd__fill_4_219 r0 *1 0,0
Xsky130_fd_sc_hd__fill_4_219 VSS VDD VDD sky130_fd_sc_hd__fill_4
* cell instance sky130_fd_sc_hd__fill_4_220 r0 *1 0,0
Xsky130_fd_sc_hd__fill_4_220 VSS VDD VDD sky130_fd_sc_hd__fill_4
* cell instance sky130_fd_sc_hd__fill_4_221 r0 *1 0,0
Xsky130_fd_sc_hd__fill_4_221 VSS VDD VDD sky130_fd_sc_hd__fill_4
* cell instance sky130_fd_sc_hd__fill_4_222 r0 *1 0,0
Xsky130_fd_sc_hd__fill_4_222 VSS VDD VDD sky130_fd_sc_hd__fill_4
* cell instance sky130_fd_sc_hd__fill_4_223 r0 *1 0,0
Xsky130_fd_sc_hd__fill_4_223 VSS VDD VDD sky130_fd_sc_hd__fill_4
* cell instance sky130_fd_sc_hd__fill_4_224 r0 *1 0,0
Xsky130_fd_sc_hd__fill_4_224 VSS VDD VDD sky130_fd_sc_hd__fill_4
* cell instance sky130_fd_sc_hd__fill_4_225 r0 *1 0,0
Xsky130_fd_sc_hd__fill_4_225 VSS VDD VDD sky130_fd_sc_hd__fill_4
* cell instance sky130_fd_sc_hd__fill_4_226 r0 *1 0,0
Xsky130_fd_sc_hd__fill_4_226 VSS VDD VDD sky130_fd_sc_hd__fill_4
* cell instance sky130_fd_sc_hd__fill_4_227 r0 *1 0,0
Xsky130_fd_sc_hd__fill_4_227 VSS VDD VDD sky130_fd_sc_hd__fill_4
* cell instance sky130_fd_sc_hd__fill_4_228 r0 *1 0,0
Xsky130_fd_sc_hd__fill_4_228 VSS VDD VDD sky130_fd_sc_hd__fill_4
* cell instance sky130_fd_sc_hd__fill_4_229 r0 *1 0,0
Xsky130_fd_sc_hd__fill_4_229 VSS VDD VDD sky130_fd_sc_hd__fill_4
* cell instance sky130_fd_sc_hd__fill_4_230 r0 *1 0,0
Xsky130_fd_sc_hd__fill_4_230 VSS VDD VDD sky130_fd_sc_hd__fill_4
* cell instance sky130_fd_sc_hd__fill_4_231 r0 *1 0,0
Xsky130_fd_sc_hd__fill_4_231 VSS VDD VDD sky130_fd_sc_hd__fill_4
* cell instance sky130_fd_sc_hd__fill_4_232 r0 *1 0,0
Xsky130_fd_sc_hd__fill_4_232 VSS VDD VDD sky130_fd_sc_hd__fill_4
* cell instance sky130_fd_sc_hd__fill_4_233 r0 *1 0,0
Xsky130_fd_sc_hd__fill_4_233 VSS VDD VDD sky130_fd_sc_hd__fill_4
* cell instance sky130_fd_sc_hd__fill_4_234 r0 *1 0,0
Xsky130_fd_sc_hd__fill_4_234 VSS VDD VDD sky130_fd_sc_hd__fill_4
* cell instance sky130_fd_sc_hd__fill_4_235 r0 *1 0,0
Xsky130_fd_sc_hd__fill_4_235 VSS VDD VDD sky130_fd_sc_hd__fill_4
* cell instance sky130_fd_sc_hd__fill_4_236 r0 *1 0,0
Xsky130_fd_sc_hd__fill_4_236 VSS VDD VDD sky130_fd_sc_hd__fill_4
* cell instance sky130_fd_sc_hd__fill_4_237 r0 *1 0,0
Xsky130_fd_sc_hd__fill_4_237 VSS VDD VDD sky130_fd_sc_hd__fill_4
* cell instance sky130_fd_sc_hd__fill_4_238 r0 *1 0,0
Xsky130_fd_sc_hd__fill_4_238 VSS VDD VDD sky130_fd_sc_hd__fill_4
* cell instance sky130_fd_sc_hd__fill_4_239 r0 *1 0,0
Xsky130_fd_sc_hd__fill_4_239 VSS VDD VDD sky130_fd_sc_hd__fill_4
* cell instance sky130_fd_sc_hd__fill_4_240 r0 *1 0,0
Xsky130_fd_sc_hd__fill_4_240 VSS VDD VDD sky130_fd_sc_hd__fill_4
* cell instance sky130_fd_sc_hd__fill_4_241 r0 *1 0,0
Xsky130_fd_sc_hd__fill_4_241 VSS VDD VDD sky130_fd_sc_hd__fill_4
* cell instance sky130_fd_sc_hd__fill_4_242 r0 *1 0,0
Xsky130_fd_sc_hd__fill_4_242 VSS VDD VDD sky130_fd_sc_hd__fill_4
* cell instance sky130_fd_sc_hd__fill_4_243 r0 *1 0,0
Xsky130_fd_sc_hd__fill_4_243 VSS VDD VDD sky130_fd_sc_hd__fill_4
* cell instance sky130_fd_sc_hd__fill_4_244 r0 *1 0,0
Xsky130_fd_sc_hd__fill_4_244 VSS VDD VDD sky130_fd_sc_hd__fill_4
* cell instance sky130_fd_sc_hd__fill_4_245 r0 *1 0,0
Xsky130_fd_sc_hd__fill_4_245 VSS VDD VDD sky130_fd_sc_hd__fill_4
* cell instance sky130_fd_sc_hd__fill_4_246 r0 *1 0,0
Xsky130_fd_sc_hd__fill_4_246 VSS VDD VDD sky130_fd_sc_hd__fill_4
* cell instance sky130_fd_sc_hd__fill_4_247 r0 *1 0,0
Xsky130_fd_sc_hd__fill_4_247 VSS VDD VDD sky130_fd_sc_hd__fill_4
* cell instance sky130_fd_sc_hd__fill_4_248 r0 *1 0,0
Xsky130_fd_sc_hd__fill_4_248 VSS VDD VDD sky130_fd_sc_hd__fill_4
* cell instance sky130_fd_sc_hd__fill_4_249 r0 *1 0,0
Xsky130_fd_sc_hd__fill_4_249 VSS VDD VDD sky130_fd_sc_hd__fill_4
* cell instance sky130_fd_sc_hd__fill_4_250 r0 *1 0,0
Xsky130_fd_sc_hd__fill_4_250 VSS VDD VDD sky130_fd_sc_hd__fill_4
* cell instance sky130_fd_sc_hd__fill_4_251 r0 *1 0,0
Xsky130_fd_sc_hd__fill_4_251 VSS VDD VDD sky130_fd_sc_hd__fill_4
* cell instance sky130_fd_sc_hd__fill_4_252 r0 *1 0,0
Xsky130_fd_sc_hd__fill_4_252 VSS VDD VDD sky130_fd_sc_hd__fill_4
* cell instance sky130_fd_sc_hd__fill_4_253 r0 *1 0,0
Xsky130_fd_sc_hd__fill_4_253 VSS VDD VDD sky130_fd_sc_hd__fill_4
* cell instance sky130_fd_sc_hd__fill_4_254 r0 *1 0,0
Xsky130_fd_sc_hd__fill_4_254 VSS VDD VDD sky130_fd_sc_hd__fill_4
* cell instance sky130_fd_sc_hd__fill_4_255 r0 *1 0,0
Xsky130_fd_sc_hd__fill_4_255 VSS VDD VDD sky130_fd_sc_hd__fill_4
* cell instance sky130_fd_sc_hd__fill_4_256 r0 *1 0,0
Xsky130_fd_sc_hd__fill_4_256 VSS VDD VDD sky130_fd_sc_hd__fill_4
* cell instance sky130_fd_sc_hd__fill_4_257 r0 *1 0,0
Xsky130_fd_sc_hd__fill_4_257 VSS VDD VDD sky130_fd_sc_hd__fill_4
* cell instance sky130_fd_sc_hd__fill_4_258 r0 *1 0,0
Xsky130_fd_sc_hd__fill_4_258 VSS VDD VDD sky130_fd_sc_hd__fill_4
* cell instance sky130_fd_sc_hd__fill_4_259 r0 *1 0,0
Xsky130_fd_sc_hd__fill_4_259 VSS VDD VDD sky130_fd_sc_hd__fill_4
* cell instance sky130_fd_sc_hd__fill_4_260 r0 *1 0,0
Xsky130_fd_sc_hd__fill_4_260 VSS VDD VDD sky130_fd_sc_hd__fill_4
* cell instance sky130_fd_sc_hd__fill_4_261 r0 *1 0,0
Xsky130_fd_sc_hd__fill_4_261 VSS VDD VDD sky130_fd_sc_hd__fill_4
* cell instance sky130_fd_sc_hd__fill_4_262 r0 *1 0,0
Xsky130_fd_sc_hd__fill_4_262 VSS VDD VDD sky130_fd_sc_hd__fill_4
* cell instance sky130_fd_sc_hd__fill_4_263 r0 *1 0,0
Xsky130_fd_sc_hd__fill_4_263 VSS VDD VDD sky130_fd_sc_hd__fill_4
* cell instance sky130_fd_sc_hd__fill_4_264 r0 *1 0,0
Xsky130_fd_sc_hd__fill_4_264 VSS VDD VDD sky130_fd_sc_hd__fill_4
* cell instance sky130_fd_sc_hd__fill_4_265 r0 *1 0,0
Xsky130_fd_sc_hd__fill_4_265 VSS VDD VDD sky130_fd_sc_hd__fill_4
* cell instance sky130_fd_sc_hd__fill_4_266 r0 *1 0,0
Xsky130_fd_sc_hd__fill_4_266 VSS VDD VDD sky130_fd_sc_hd__fill_4
* cell instance sky130_fd_sc_hd__fill_4_267 r0 *1 0,0
Xsky130_fd_sc_hd__fill_4_267 VSS VDD VDD sky130_fd_sc_hd__fill_4
* cell instance sky130_fd_sc_hd__fill_4_268 r0 *1 0,0
Xsky130_fd_sc_hd__fill_4_268 VSS VDD VDD sky130_fd_sc_hd__fill_4
* cell instance sky130_fd_sc_hd__fill_4_269 r0 *1 0,0
Xsky130_fd_sc_hd__fill_4_269 VSS VDD VDD sky130_fd_sc_hd__fill_4
* cell instance sky130_fd_sc_hd__fill_4_270 r0 *1 0,0
Xsky130_fd_sc_hd__fill_4_270 VSS VDD VDD sky130_fd_sc_hd__fill_4
* cell instance sky130_fd_sc_hd__fill_4_271 r0 *1 0,0
Xsky130_fd_sc_hd__fill_4_271 VSS VDD VDD sky130_fd_sc_hd__fill_4
* cell instance sky130_fd_sc_hd__fill_4_272 r0 *1 0,0
Xsky130_fd_sc_hd__fill_4_272 VSS VDD VDD sky130_fd_sc_hd__fill_4
* cell instance sky130_fd_sc_hd__fill_4_273 r0 *1 0,0
Xsky130_fd_sc_hd__fill_4_273 VSS VDD VDD sky130_fd_sc_hd__fill_4
* cell instance sky130_fd_sc_hd__fill_4_274 r0 *1 0,0
Xsky130_fd_sc_hd__fill_4_274 VSS VDD VDD sky130_fd_sc_hd__fill_4
* cell instance sky130_fd_sc_hd__fill_4_275 r0 *1 0,0
Xsky130_fd_sc_hd__fill_4_275 VSS VDD VDD sky130_fd_sc_hd__fill_4
* cell instance sky130_fd_sc_hd__fill_4_276 r0 *1 0,0
Xsky130_fd_sc_hd__fill_4_276 VSS VDD VDD sky130_fd_sc_hd__fill_4
* cell instance sky130_fd_sc_hd__fill_4_277 r0 *1 0,0
Xsky130_fd_sc_hd__fill_4_277 VSS VDD VDD sky130_fd_sc_hd__fill_4
* cell instance sky130_fd_sc_hd__fill_4_278 r0 *1 0,0
Xsky130_fd_sc_hd__fill_4_278 VSS VDD VDD sky130_fd_sc_hd__fill_4
* cell instance sky130_fd_sc_hd__fill_4_279 r0 *1 0,0
Xsky130_fd_sc_hd__fill_4_279 VSS VDD VDD sky130_fd_sc_hd__fill_4
* cell instance sky130_fd_sc_hd__fill_4_280 r0 *1 0,0
Xsky130_fd_sc_hd__fill_4_280 VSS VDD VDD sky130_fd_sc_hd__fill_4
* cell instance sky130_fd_sc_hd__fill_4_281 r0 *1 0,0
Xsky130_fd_sc_hd__fill_4_281 VSS VDD VDD sky130_fd_sc_hd__fill_4
* cell instance sky130_fd_sc_hd__fill_4_282 r0 *1 0,0
Xsky130_fd_sc_hd__fill_4_282 VSS VDD VDD sky130_fd_sc_hd__fill_4
* cell instance sky130_fd_sc_hd__fill_4_283 r0 *1 0,0
Xsky130_fd_sc_hd__fill_4_283 VSS VDD VDD sky130_fd_sc_hd__fill_4
* cell instance sky130_fd_sc_hd__fill_4_284 r0 *1 0,0
Xsky130_fd_sc_hd__fill_4_284 VSS VDD VDD sky130_fd_sc_hd__fill_4
* cell instance sky130_fd_sc_hd__fill_4_285 r0 *1 0,0
Xsky130_fd_sc_hd__fill_4_285 VSS VDD VDD sky130_fd_sc_hd__fill_4
* cell instance sky130_fd_sc_hd__fill_4_286 r0 *1 0,0
Xsky130_fd_sc_hd__fill_4_286 VSS VDD VDD sky130_fd_sc_hd__fill_4
* cell instance sky130_fd_sc_hd__fill_4_287 r0 *1 0,0
Xsky130_fd_sc_hd__fill_4_287 VSS VDD VDD sky130_fd_sc_hd__fill_4
* cell instance sky130_fd_sc_hd__fill_4_288 r0 *1 0,0
Xsky130_fd_sc_hd__fill_4_288 VSS VDD VDD sky130_fd_sc_hd__fill_4
* cell instance sky130_fd_sc_hd__fill_4_289 r0 *1 0,0
Xsky130_fd_sc_hd__fill_4_289 VSS VDD VDD sky130_fd_sc_hd__fill_4
* cell instance sky130_fd_sc_hd__fill_4_290 r0 *1 0,0
Xsky130_fd_sc_hd__fill_4_290 VSS VDD VDD sky130_fd_sc_hd__fill_4
* cell instance sky130_fd_sc_hd__fill_4_291 r0 *1 0,0
Xsky130_fd_sc_hd__fill_4_291 VSS VDD VDD sky130_fd_sc_hd__fill_4
* cell instance sky130_fd_sc_hd__fill_4_292 r0 *1 0,0
Xsky130_fd_sc_hd__fill_4_292 VSS VDD VDD sky130_fd_sc_hd__fill_4
* cell instance sky130_fd_sc_hd__fill_4_293 r0 *1 0,0
Xsky130_fd_sc_hd__fill_4_293 VSS VDD VDD sky130_fd_sc_hd__fill_4
* cell instance sky130_fd_sc_hd__fill_4_294 r0 *1 0,0
Xsky130_fd_sc_hd__fill_4_294 VSS VDD VDD sky130_fd_sc_hd__fill_4
* cell instance sky130_fd_sc_hd__fill_4_295 r0 *1 0,0
Xsky130_fd_sc_hd__fill_4_295 VSS VDD VDD sky130_fd_sc_hd__fill_4
* cell instance sky130_fd_sc_hd__fill_4_296 r0 *1 0,0
Xsky130_fd_sc_hd__fill_4_296 VSS VDD VDD sky130_fd_sc_hd__fill_4
* cell instance sky130_fd_sc_hd__fill_4_297 r0 *1 0,0
Xsky130_fd_sc_hd__fill_4_297 VSS VDD VDD sky130_fd_sc_hd__fill_4
* cell instance sky130_fd_sc_hd__fill_4_298 r0 *1 0,0
Xsky130_fd_sc_hd__fill_4_298 VSS VDD VDD sky130_fd_sc_hd__fill_4
* cell instance sky130_fd_sc_hd__fill_4_299 r0 *1 0,0
Xsky130_fd_sc_hd__fill_4_299 VSS VDD VDD sky130_fd_sc_hd__fill_4
* cell instance sky130_fd_sc_hd__fill_4_300 r0 *1 0,0
Xsky130_fd_sc_hd__fill_4_300 VSS VDD VDD sky130_fd_sc_hd__fill_4
* cell instance sky130_fd_sc_hd__fill_4_301 r0 *1 0,0
Xsky130_fd_sc_hd__fill_4_301 VSS VDD VDD sky130_fd_sc_hd__fill_4
* cell instance sky130_fd_sc_hd__fill_4_302 r0 *1 0,0
Xsky130_fd_sc_hd__fill_4_302 VSS VDD VDD sky130_fd_sc_hd__fill_4
* cell instance sky130_fd_sc_hd__fill_4_303 r0 *1 0,0
Xsky130_fd_sc_hd__fill_4_303 VSS VDD VDD sky130_fd_sc_hd__fill_4
* cell instance sky130_fd_sc_hd__fill_4_304 r0 *1 0,0
Xsky130_fd_sc_hd__fill_4_304 VSS VDD VDD sky130_fd_sc_hd__fill_4
* cell instance sky130_fd_sc_hd__fill_4_305 r0 *1 0,0
Xsky130_fd_sc_hd__fill_4_305 VSS VDD VDD sky130_fd_sc_hd__fill_4
* cell instance sky130_fd_sc_hd__fill_4_306 r0 *1 0,0
Xsky130_fd_sc_hd__fill_4_306 VSS VDD VDD sky130_fd_sc_hd__fill_4
* cell instance sky130_fd_sc_hd__fill_4_307 r0 *1 0,0
Xsky130_fd_sc_hd__fill_4_307 VSS VDD VDD sky130_fd_sc_hd__fill_4
* cell instance sky130_fd_sc_hd__fill_4_308 r0 *1 0,0
Xsky130_fd_sc_hd__fill_4_308 VSS VDD VDD sky130_fd_sc_hd__fill_4
* cell instance sky130_fd_sc_hd__fill_4_309 r0 *1 0,0
Xsky130_fd_sc_hd__fill_4_309 VSS VDD VDD sky130_fd_sc_hd__fill_4
* cell instance sky130_fd_sc_hd__fill_4_310 r0 *1 0,0
Xsky130_fd_sc_hd__fill_4_310 VSS VDD VDD sky130_fd_sc_hd__fill_4
* cell instance sky130_fd_sc_hd__fill_4_311 r0 *1 0,0
Xsky130_fd_sc_hd__fill_4_311 VSS VDD VDD sky130_fd_sc_hd__fill_4
* cell instance sky130_fd_sc_hd__fill_4_312 r0 *1 0,0
Xsky130_fd_sc_hd__fill_4_312 VSS VDD VDD sky130_fd_sc_hd__fill_4
* cell instance sky130_fd_sc_hd__fill_4_313 r0 *1 0,0
Xsky130_fd_sc_hd__fill_4_313 VSS VDD VDD sky130_fd_sc_hd__fill_4
* cell instance sky130_fd_sc_hd__fill_4_314 r0 *1 0,0
Xsky130_fd_sc_hd__fill_4_314 VSS VDD VDD sky130_fd_sc_hd__fill_4
* cell instance sky130_fd_sc_hd__fill_4_315 r0 *1 0,0
Xsky130_fd_sc_hd__fill_4_315 VSS VDD VDD sky130_fd_sc_hd__fill_4
* cell instance sky130_fd_sc_hd__fill_4_316 r0 *1 0,0
Xsky130_fd_sc_hd__fill_4_316 VSS VDD VDD sky130_fd_sc_hd__fill_4
* cell instance sky130_fd_sc_hd__fill_4_317 r0 *1 0,0
Xsky130_fd_sc_hd__fill_4_317 VSS VDD VDD sky130_fd_sc_hd__fill_4
* cell instance sky130_fd_sc_hd__fill_4_318 r0 *1 0,0
Xsky130_fd_sc_hd__fill_4_318 VSS VDD VDD sky130_fd_sc_hd__fill_4
* cell instance sky130_fd_sc_hd__fill_4_319 r0 *1 0,0
Xsky130_fd_sc_hd__fill_4_319 VSS VDD VDD sky130_fd_sc_hd__fill_4
* cell instance sky130_fd_sc_hd__fill_4_320 r0 *1 0,0
Xsky130_fd_sc_hd__fill_4_320 VSS VDD VDD sky130_fd_sc_hd__fill_4
* cell instance sky130_fd_sc_hd__fill_4_321 r0 *1 0,0
Xsky130_fd_sc_hd__fill_4_321 VSS VDD VDD sky130_fd_sc_hd__fill_4
* cell instance sky130_fd_sc_hd__fill_4_322 r0 *1 0,0
Xsky130_fd_sc_hd__fill_4_322 VSS VDD VDD sky130_fd_sc_hd__fill_4
* cell instance sky130_fd_sc_hd__fill_4_323 r0 *1 0,0
Xsky130_fd_sc_hd__fill_4_323 VSS VDD VDD sky130_fd_sc_hd__fill_4
* cell instance sky130_fd_sc_hd__fill_4_324 r0 *1 0,0
Xsky130_fd_sc_hd__fill_4_324 VSS VDD VDD sky130_fd_sc_hd__fill_4
* cell instance sky130_fd_sc_hd__fill_4_325 r0 *1 0,0
Xsky130_fd_sc_hd__fill_4_325 VSS VDD VDD sky130_fd_sc_hd__fill_4
* cell instance sky130_fd_sc_hd__fill_4_326 r0 *1 0,0
Xsky130_fd_sc_hd__fill_4_326 VSS VDD VDD sky130_fd_sc_hd__fill_4
* cell instance sky130_fd_sc_hd__fill_8_0 r0 *1 0,0
Xsky130_fd_sc_hd__fill_8_0 VSS VDD VDD sky130_fd_sc_hd__fill_8
* cell instance sky130_fd_sc_hd__fill_8_1 r0 *1 0,0
Xsky130_fd_sc_hd__fill_8_1 VSS VDD VDD sky130_fd_sc_hd__fill_8
* cell instance sky130_fd_sc_hd__fill_8_2 r0 *1 0,0
Xsky130_fd_sc_hd__fill_8_2 VSS VDD VDD sky130_fd_sc_hd__fill_8
* cell instance sky130_fd_sc_hd__fill_8_3 r0 *1 0,0
Xsky130_fd_sc_hd__fill_8_3 VSS VDD VDD sky130_fd_sc_hd__fill_8
* cell instance sky130_fd_sc_hd__fill_8_4 r0 *1 0,0
Xsky130_fd_sc_hd__fill_8_4 VSS VDD VDD sky130_fd_sc_hd__fill_8
* cell instance sky130_fd_sc_hd__fill_8_5 r0 *1 0,0
Xsky130_fd_sc_hd__fill_8_5 VSS VDD VDD sky130_fd_sc_hd__fill_8
* cell instance sky130_fd_sc_hd__fill_8_6 r0 *1 0,0
Xsky130_fd_sc_hd__fill_8_6 VSS VDD VDD sky130_fd_sc_hd__fill_8
* cell instance sky130_fd_sc_hd__fill_8_7 r0 *1 0,0
Xsky130_fd_sc_hd__fill_8_7 VSS VDD VDD sky130_fd_sc_hd__fill_8
* cell instance sky130_fd_sc_hd__fill_8_8 r0 *1 0,0
Xsky130_fd_sc_hd__fill_8_8 VSS VDD VDD sky130_fd_sc_hd__fill_8
* cell instance sky130_fd_sc_hd__fill_8_9 r0 *1 0,0
Xsky130_fd_sc_hd__fill_8_9 VSS VDD VDD sky130_fd_sc_hd__fill_8
* cell instance sky130_fd_sc_hd__fill_8_10 r0 *1 0,0
Xsky130_fd_sc_hd__fill_8_10 VSS VDD VDD sky130_fd_sc_hd__fill_8
* cell instance sky130_fd_sc_hd__fill_8_11 r0 *1 0,0
Xsky130_fd_sc_hd__fill_8_11 VSS VDD VDD sky130_fd_sc_hd__fill_8
* cell instance sky130_fd_sc_hd__fill_8_12 r0 *1 0,0
Xsky130_fd_sc_hd__fill_8_12 VSS VDD VDD sky130_fd_sc_hd__fill_8
* cell instance sky130_fd_sc_hd__fill_8_13 r0 *1 0,0
Xsky130_fd_sc_hd__fill_8_13 VSS VDD VDD sky130_fd_sc_hd__fill_8
* cell instance sky130_fd_sc_hd__fill_8_14 r0 *1 0,0
Xsky130_fd_sc_hd__fill_8_14 VSS VDD VDD sky130_fd_sc_hd__fill_8
* cell instance sky130_fd_sc_hd__fill_8_15 r0 *1 0,0
Xsky130_fd_sc_hd__fill_8_15 VSS VDD VDD sky130_fd_sc_hd__fill_8
* cell instance sky130_fd_sc_hd__fill_8_16 r0 *1 0,0
Xsky130_fd_sc_hd__fill_8_16 VSS VDD VDD sky130_fd_sc_hd__fill_8
* cell instance sky130_fd_sc_hd__fill_8_17 r0 *1 0,0
Xsky130_fd_sc_hd__fill_8_17 VSS VDD VDD sky130_fd_sc_hd__fill_8
* cell instance sky130_fd_sc_hd__fill_8_18 r0 *1 0,0
Xsky130_fd_sc_hd__fill_8_18 VSS VDD VDD sky130_fd_sc_hd__fill_8
* cell instance sky130_fd_sc_hd__fill_8_19 r0 *1 0,0
Xsky130_fd_sc_hd__fill_8_19 VSS VDD VDD sky130_fd_sc_hd__fill_8
* cell instance sky130_fd_sc_hd__fill_8_20 r0 *1 0,0
Xsky130_fd_sc_hd__fill_8_20 VSS VDD VDD sky130_fd_sc_hd__fill_8
* cell instance sky130_fd_sc_hd__fill_8_21 r0 *1 0,0
Xsky130_fd_sc_hd__fill_8_21 VSS VDD VDD sky130_fd_sc_hd__fill_8
* cell instance sky130_fd_sc_hd__fill_8_22 r0 *1 0,0
Xsky130_fd_sc_hd__fill_8_22 VSS VDD VDD sky130_fd_sc_hd__fill_8
* cell instance sky130_fd_sc_hd__fill_8_23 r0 *1 0,0
Xsky130_fd_sc_hd__fill_8_23 VSS VDD VDD sky130_fd_sc_hd__fill_8
* cell instance sky130_fd_sc_hd__fill_8_24 r0 *1 0,0
Xsky130_fd_sc_hd__fill_8_24 VSS VDD VDD sky130_fd_sc_hd__fill_8
* cell instance sky130_fd_sc_hd__fill_8_25 r0 *1 0,0
Xsky130_fd_sc_hd__fill_8_25 VSS VDD VDD sky130_fd_sc_hd__fill_8
* cell instance sky130_fd_sc_hd__fill_8_26 r0 *1 0,0
Xsky130_fd_sc_hd__fill_8_26 VSS VDD VDD sky130_fd_sc_hd__fill_8
* cell instance sky130_fd_sc_hd__fill_8_27 r0 *1 0,0
Xsky130_fd_sc_hd__fill_8_27 VSS VDD VDD sky130_fd_sc_hd__fill_8
* cell instance sky130_fd_sc_hd__fill_8_28 r0 *1 0,0
Xsky130_fd_sc_hd__fill_8_28 VSS VDD VDD sky130_fd_sc_hd__fill_8
* cell instance sky130_fd_sc_hd__fill_8_29 r0 *1 0,0
Xsky130_fd_sc_hd__fill_8_29 VSS VDD VDD sky130_fd_sc_hd__fill_8
* cell instance sky130_fd_sc_hd__fill_8_30 r0 *1 0,0
Xsky130_fd_sc_hd__fill_8_30 VSS VDD VDD sky130_fd_sc_hd__fill_8
* cell instance sky130_fd_sc_hd__fill_8_31 r0 *1 0,0
Xsky130_fd_sc_hd__fill_8_31 VSS VDD VDD sky130_fd_sc_hd__fill_8
* cell instance sky130_fd_sc_hd__fill_8_32 r0 *1 0,0
Xsky130_fd_sc_hd__fill_8_32 VSS VDD VDD sky130_fd_sc_hd__fill_8
* cell instance sky130_fd_sc_hd__fill_8_33 r0 *1 0,0
Xsky130_fd_sc_hd__fill_8_33 VSS VDD VDD sky130_fd_sc_hd__fill_8
* cell instance sky130_fd_sc_hd__fill_8_34 r0 *1 0,0
Xsky130_fd_sc_hd__fill_8_34 VSS VDD VDD sky130_fd_sc_hd__fill_8
* cell instance sky130_fd_sc_hd__fill_8_35 r0 *1 0,0
Xsky130_fd_sc_hd__fill_8_35 VSS VDD VDD sky130_fd_sc_hd__fill_8
* cell instance sky130_fd_sc_hd__fill_8_36 r0 *1 0,0
Xsky130_fd_sc_hd__fill_8_36 VSS VDD VDD sky130_fd_sc_hd__fill_8
* cell instance sky130_fd_sc_hd__fill_8_37 r0 *1 0,0
Xsky130_fd_sc_hd__fill_8_37 VSS VDD VDD sky130_fd_sc_hd__fill_8
* cell instance sky130_fd_sc_hd__fill_8_38 r0 *1 0,0
Xsky130_fd_sc_hd__fill_8_38 VSS VDD VDD sky130_fd_sc_hd__fill_8
* cell instance sky130_fd_sc_hd__fill_8_39 r0 *1 0,0
Xsky130_fd_sc_hd__fill_8_39 VSS VDD VDD sky130_fd_sc_hd__fill_8
* cell instance sky130_fd_sc_hd__fill_8_40 r0 *1 0,0
Xsky130_fd_sc_hd__fill_8_40 VSS VDD VDD sky130_fd_sc_hd__fill_8
* cell instance sky130_fd_sc_hd__fill_8_41 r0 *1 0,0
Xsky130_fd_sc_hd__fill_8_41 VSS VDD VDD sky130_fd_sc_hd__fill_8
* cell instance sky130_fd_sc_hd__fill_8_42 r0 *1 0,0
Xsky130_fd_sc_hd__fill_8_42 VSS VDD VDD sky130_fd_sc_hd__fill_8
* cell instance sky130_fd_sc_hd__fill_8_43 r0 *1 0,0
Xsky130_fd_sc_hd__fill_8_43 VSS VDD VDD sky130_fd_sc_hd__fill_8
* cell instance sky130_fd_sc_hd__fill_8_44 r0 *1 0,0
Xsky130_fd_sc_hd__fill_8_44 VSS VDD VDD sky130_fd_sc_hd__fill_8
* cell instance sky130_fd_sc_hd__fill_8_45 r0 *1 0,0
Xsky130_fd_sc_hd__fill_8_45 VSS VDD VDD sky130_fd_sc_hd__fill_8
* cell instance sky130_fd_sc_hd__fill_8_46 r0 *1 0,0
Xsky130_fd_sc_hd__fill_8_46 VSS VDD VDD sky130_fd_sc_hd__fill_8
* cell instance sky130_fd_sc_hd__fill_8_47 r0 *1 0,0
Xsky130_fd_sc_hd__fill_8_47 VSS VDD VDD sky130_fd_sc_hd__fill_8
* cell instance sky130_fd_sc_hd__fill_8_48 r0 *1 0,0
Xsky130_fd_sc_hd__fill_8_48 VSS VDD VDD sky130_fd_sc_hd__fill_8
* cell instance sky130_fd_sc_hd__fill_8_49 r0 *1 0,0
Xsky130_fd_sc_hd__fill_8_49 VSS VDD VDD sky130_fd_sc_hd__fill_8
* cell instance sky130_fd_sc_hd__fill_8_50 r0 *1 0,0
Xsky130_fd_sc_hd__fill_8_50 VSS VDD VDD sky130_fd_sc_hd__fill_8
* cell instance sky130_fd_sc_hd__fill_8_51 r0 *1 0,0
Xsky130_fd_sc_hd__fill_8_51 VSS VDD VDD sky130_fd_sc_hd__fill_8
* cell instance sky130_fd_sc_hd__fill_8_52 r0 *1 0,0
Xsky130_fd_sc_hd__fill_8_52 VSS VDD VDD sky130_fd_sc_hd__fill_8
* cell instance sky130_fd_sc_hd__fill_8_53 r0 *1 0,0
Xsky130_fd_sc_hd__fill_8_53 VSS VDD VDD sky130_fd_sc_hd__fill_8
* cell instance sky130_fd_sc_hd__fill_8_54 r0 *1 0,0
Xsky130_fd_sc_hd__fill_8_54 VSS VDD VDD sky130_fd_sc_hd__fill_8
* cell instance sky130_fd_sc_hd__fill_8_55 r0 *1 0,0
Xsky130_fd_sc_hd__fill_8_55 VSS VDD VDD sky130_fd_sc_hd__fill_8
* cell instance sky130_fd_sc_hd__fill_8_56 r0 *1 0,0
Xsky130_fd_sc_hd__fill_8_56 VSS VDD VDD sky130_fd_sc_hd__fill_8
* cell instance sky130_fd_sc_hd__fill_8_57 r0 *1 0,0
Xsky130_fd_sc_hd__fill_8_57 VSS VDD VDD sky130_fd_sc_hd__fill_8
* cell instance sky130_fd_sc_hd__fill_8_58 r0 *1 0,0
Xsky130_fd_sc_hd__fill_8_58 VSS VDD VDD sky130_fd_sc_hd__fill_8
* cell instance sky130_fd_sc_hd__fill_8_59 r0 *1 0,0
Xsky130_fd_sc_hd__fill_8_59 VSS VDD VDD sky130_fd_sc_hd__fill_8
* cell instance sky130_fd_sc_hd__fill_8_60 r0 *1 0,0
Xsky130_fd_sc_hd__fill_8_60 VSS VDD VDD sky130_fd_sc_hd__fill_8
* cell instance sky130_fd_sc_hd__fill_8_61 r0 *1 0,0
Xsky130_fd_sc_hd__fill_8_61 VSS VDD VDD sky130_fd_sc_hd__fill_8
* cell instance sky130_fd_sc_hd__fill_8_62 r0 *1 0,0
Xsky130_fd_sc_hd__fill_8_62 VSS VDD VDD sky130_fd_sc_hd__fill_8
* cell instance sky130_fd_sc_hd__fill_8_63 r0 *1 0,0
Xsky130_fd_sc_hd__fill_8_63 VSS VDD VDD sky130_fd_sc_hd__fill_8
* cell instance sky130_fd_sc_hd__fill_8_64 r0 *1 0,0
Xsky130_fd_sc_hd__fill_8_64 VSS VDD VDD sky130_fd_sc_hd__fill_8
* cell instance sky130_fd_sc_hd__fill_8_65 r0 *1 0,0
Xsky130_fd_sc_hd__fill_8_65 VSS VDD VDD sky130_fd_sc_hd__fill_8
* cell instance sky130_fd_sc_hd__fill_8_66 r0 *1 0,0
Xsky130_fd_sc_hd__fill_8_66 VSS VDD VDD sky130_fd_sc_hd__fill_8
* cell instance sky130_fd_sc_hd__fill_8_67 r0 *1 0,0
Xsky130_fd_sc_hd__fill_8_67 VSS VDD VDD sky130_fd_sc_hd__fill_8
* cell instance sky130_fd_sc_hd__fill_8_68 r0 *1 0,0
Xsky130_fd_sc_hd__fill_8_68 VSS VDD VDD sky130_fd_sc_hd__fill_8
* cell instance sky130_fd_sc_hd__fill_8_69 r0 *1 0,0
Xsky130_fd_sc_hd__fill_8_69 VSS VDD VDD sky130_fd_sc_hd__fill_8
* cell instance sky130_fd_sc_hd__fill_8_70 r0 *1 0,0
Xsky130_fd_sc_hd__fill_8_70 VSS VDD VDD sky130_fd_sc_hd__fill_8
* cell instance sky130_fd_sc_hd__fill_8_71 r0 *1 0,0
Xsky130_fd_sc_hd__fill_8_71 VSS VDD VDD sky130_fd_sc_hd__fill_8
* cell instance sky130_fd_sc_hd__fill_8_72 r0 *1 0,0
Xsky130_fd_sc_hd__fill_8_72 VSS VDD VDD sky130_fd_sc_hd__fill_8
* cell instance sky130_fd_sc_hd__fill_8_73 r0 *1 0,0
Xsky130_fd_sc_hd__fill_8_73 VSS VDD VDD sky130_fd_sc_hd__fill_8
* cell instance sky130_fd_sc_hd__fill_8_74 r0 *1 0,0
Xsky130_fd_sc_hd__fill_8_74 VSS VDD VDD sky130_fd_sc_hd__fill_8
* cell instance sky130_fd_sc_hd__fill_8_75 r0 *1 0,0
Xsky130_fd_sc_hd__fill_8_75 VSS VDD VDD sky130_fd_sc_hd__fill_8
* cell instance sky130_fd_sc_hd__fill_8_76 r0 *1 0,0
Xsky130_fd_sc_hd__fill_8_76 VSS VDD VDD sky130_fd_sc_hd__fill_8
* cell instance sky130_fd_sc_hd__fill_8_77 r0 *1 0,0
Xsky130_fd_sc_hd__fill_8_77 VSS VDD VDD sky130_fd_sc_hd__fill_8
* cell instance sky130_fd_sc_hd__fill_8_78 r0 *1 0,0
Xsky130_fd_sc_hd__fill_8_78 VSS VDD VDD sky130_fd_sc_hd__fill_8
* cell instance sky130_fd_sc_hd__fill_8_79 r0 *1 0,0
Xsky130_fd_sc_hd__fill_8_79 VSS VDD VDD sky130_fd_sc_hd__fill_8
* cell instance sky130_fd_sc_hd__fill_8_80 r0 *1 0,0
Xsky130_fd_sc_hd__fill_8_80 VSS VDD VDD sky130_fd_sc_hd__fill_8
* cell instance sky130_fd_sc_hd__fill_8_81 r0 *1 0,0
Xsky130_fd_sc_hd__fill_8_81 VSS VDD VDD sky130_fd_sc_hd__fill_8
* cell instance sky130_fd_sc_hd__fill_8_82 r0 *1 0,0
Xsky130_fd_sc_hd__fill_8_82 VSS VDD VDD sky130_fd_sc_hd__fill_8
* cell instance sky130_fd_sc_hd__fill_8_83 r0 *1 0,0
Xsky130_fd_sc_hd__fill_8_83 VSS VDD VDD sky130_fd_sc_hd__fill_8
* cell instance sky130_fd_sc_hd__fill_8_84 r0 *1 0,0
Xsky130_fd_sc_hd__fill_8_84 VSS VDD VDD sky130_fd_sc_hd__fill_8
* cell instance sky130_fd_sc_hd__fill_8_85 r0 *1 0,0
Xsky130_fd_sc_hd__fill_8_85 VSS VDD VDD sky130_fd_sc_hd__fill_8
* cell instance sky130_fd_sc_hd__fill_8_86 r0 *1 0,0
Xsky130_fd_sc_hd__fill_8_86 VSS VDD VDD sky130_fd_sc_hd__fill_8
* cell instance sky130_fd_sc_hd__fill_8_87 r0 *1 0,0
Xsky130_fd_sc_hd__fill_8_87 VSS VDD VDD sky130_fd_sc_hd__fill_8
* cell instance sky130_fd_sc_hd__fill_8_88 r0 *1 0,0
Xsky130_fd_sc_hd__fill_8_88 VSS VDD VDD sky130_fd_sc_hd__fill_8
* cell instance sky130_fd_sc_hd__fill_8_89 r0 *1 0,0
Xsky130_fd_sc_hd__fill_8_89 VSS VDD VDD sky130_fd_sc_hd__fill_8
* cell instance sky130_fd_sc_hd__fill_8_90 r0 *1 0,0
Xsky130_fd_sc_hd__fill_8_90 VSS VDD VDD sky130_fd_sc_hd__fill_8
* cell instance sky130_fd_sc_hd__fill_8_91 r0 *1 0,0
Xsky130_fd_sc_hd__fill_8_91 VSS VDD VDD sky130_fd_sc_hd__fill_8
* cell instance sky130_fd_sc_hd__fill_8_92 r0 *1 0,0
Xsky130_fd_sc_hd__fill_8_92 VSS VDD VDD sky130_fd_sc_hd__fill_8
* cell instance sky130_fd_sc_hd__fill_8_93 r0 *1 0,0
Xsky130_fd_sc_hd__fill_8_93 VSS VDD VDD sky130_fd_sc_hd__fill_8
* cell instance sky130_fd_sc_hd__fill_8_94 r0 *1 0,0
Xsky130_fd_sc_hd__fill_8_94 VSS VDD VDD sky130_fd_sc_hd__fill_8
* cell instance sky130_fd_sc_hd__fill_8_95 r0 *1 0,0
Xsky130_fd_sc_hd__fill_8_95 VSS VDD VDD sky130_fd_sc_hd__fill_8
* cell instance sky130_fd_sc_hd__fill_8_96 r0 *1 0,0
Xsky130_fd_sc_hd__fill_8_96 VSS VDD VDD sky130_fd_sc_hd__fill_8
* cell instance sky130_fd_sc_hd__fill_8_97 r0 *1 0,0
Xsky130_fd_sc_hd__fill_8_97 VSS VDD VDD sky130_fd_sc_hd__fill_8
* cell instance sky130_fd_sc_hd__fill_8_98 r0 *1 0,0
Xsky130_fd_sc_hd__fill_8_98 VSS VDD VDD sky130_fd_sc_hd__fill_8
* cell instance sky130_fd_sc_hd__fill_8_99 r0 *1 0,0
Xsky130_fd_sc_hd__fill_8_99 VSS VDD VDD sky130_fd_sc_hd__fill_8
* cell instance sky130_fd_sc_hd__fill_8_100 r0 *1 0,0
Xsky130_fd_sc_hd__fill_8_100 VSS VDD VDD sky130_fd_sc_hd__fill_8
* cell instance sky130_fd_sc_hd__fill_8_101 r0 *1 0,0
Xsky130_fd_sc_hd__fill_8_101 VSS VDD VDD sky130_fd_sc_hd__fill_8
* cell instance sky130_fd_sc_hd__fill_8_102 r0 *1 0,0
Xsky130_fd_sc_hd__fill_8_102 VSS VDD VDD sky130_fd_sc_hd__fill_8
* cell instance sky130_fd_sc_hd__fill_8_103 r0 *1 0,0
Xsky130_fd_sc_hd__fill_8_103 VSS VDD VDD sky130_fd_sc_hd__fill_8
* cell instance sky130_fd_sc_hd__fill_8_104 r0 *1 0,0
Xsky130_fd_sc_hd__fill_8_104 VSS VDD VDD sky130_fd_sc_hd__fill_8
* cell instance sky130_fd_sc_hd__fill_8_105 r0 *1 0,0
Xsky130_fd_sc_hd__fill_8_105 VSS VDD VDD sky130_fd_sc_hd__fill_8
* cell instance sky130_fd_sc_hd__fill_8_106 r0 *1 0,0
Xsky130_fd_sc_hd__fill_8_106 VSS VDD VDD sky130_fd_sc_hd__fill_8
* cell instance sky130_fd_sc_hd__fill_8_107 r0 *1 0,0
Xsky130_fd_sc_hd__fill_8_107 VSS VDD VDD sky130_fd_sc_hd__fill_8
* cell instance sky130_fd_sc_hd__fill_8_108 r0 *1 0,0
Xsky130_fd_sc_hd__fill_8_108 VSS VDD VDD sky130_fd_sc_hd__fill_8
* cell instance sky130_fd_sc_hd__fill_8_109 r0 *1 0,0
Xsky130_fd_sc_hd__fill_8_109 VSS VDD VDD sky130_fd_sc_hd__fill_8
* cell instance sky130_fd_sc_hd__fill_8_110 r0 *1 0,0
Xsky130_fd_sc_hd__fill_8_110 VSS VDD VDD sky130_fd_sc_hd__fill_8
* cell instance sky130_fd_sc_hd__fill_8_111 r0 *1 0,0
Xsky130_fd_sc_hd__fill_8_111 VSS VDD VDD sky130_fd_sc_hd__fill_8
* cell instance sky130_fd_sc_hd__fill_8_112 r0 *1 0,0
Xsky130_fd_sc_hd__fill_8_112 VSS VDD VDD sky130_fd_sc_hd__fill_8
* cell instance sky130_fd_sc_hd__fill_8_113 r0 *1 0,0
Xsky130_fd_sc_hd__fill_8_113 VSS VDD VDD sky130_fd_sc_hd__fill_8
* cell instance sky130_fd_sc_hd__fill_8_114 r0 *1 0,0
Xsky130_fd_sc_hd__fill_8_114 VSS VDD VDD sky130_fd_sc_hd__fill_8
* cell instance sky130_fd_sc_hd__fill_8_115 r0 *1 0,0
Xsky130_fd_sc_hd__fill_8_115 VSS VDD VDD sky130_fd_sc_hd__fill_8
* cell instance sky130_fd_sc_hd__fill_8_116 r0 *1 0,0
Xsky130_fd_sc_hd__fill_8_116 VSS VDD VDD sky130_fd_sc_hd__fill_8
* cell instance sky130_fd_sc_hd__fill_8_117 r0 *1 0,0
Xsky130_fd_sc_hd__fill_8_117 VSS VDD VDD sky130_fd_sc_hd__fill_8
* cell instance sky130_fd_sc_hd__fill_8_118 r0 *1 0,0
Xsky130_fd_sc_hd__fill_8_118 VSS VDD VDD sky130_fd_sc_hd__fill_8
* cell instance sky130_fd_sc_hd__fill_8_119 r0 *1 0,0
Xsky130_fd_sc_hd__fill_8_119 VSS VDD VDD sky130_fd_sc_hd__fill_8
* cell instance sky130_fd_sc_hd__fill_8_120 r0 *1 0,0
Xsky130_fd_sc_hd__fill_8_120 VSS VDD VDD sky130_fd_sc_hd__fill_8
* cell instance sky130_fd_sc_hd__fill_8_121 r0 *1 0,0
Xsky130_fd_sc_hd__fill_8_121 VSS VDD VDD sky130_fd_sc_hd__fill_8
* cell instance sky130_fd_sc_hd__fill_8_122 r0 *1 0,0
Xsky130_fd_sc_hd__fill_8_122 VSS VDD VDD sky130_fd_sc_hd__fill_8
* cell instance sky130_fd_sc_hd__fill_8_123 r0 *1 0,0
Xsky130_fd_sc_hd__fill_8_123 VSS VDD VDD sky130_fd_sc_hd__fill_8
* cell instance sky130_fd_sc_hd__fill_8_124 r0 *1 0,0
Xsky130_fd_sc_hd__fill_8_124 VSS VDD VDD sky130_fd_sc_hd__fill_8
* cell instance sky130_fd_sc_hd__fill_8_125 r0 *1 0,0
Xsky130_fd_sc_hd__fill_8_125 VSS VDD VDD sky130_fd_sc_hd__fill_8
* cell instance sky130_fd_sc_hd__fill_8_126 r0 *1 0,0
Xsky130_fd_sc_hd__fill_8_126 VSS VDD VDD sky130_fd_sc_hd__fill_8
* cell instance sky130_fd_sc_hd__fill_8_127 r0 *1 0,0
Xsky130_fd_sc_hd__fill_8_127 VSS VDD VDD sky130_fd_sc_hd__fill_8
* cell instance sky130_fd_sc_hd__fill_8_128 r0 *1 0,0
Xsky130_fd_sc_hd__fill_8_128 VSS VDD VDD sky130_fd_sc_hd__fill_8
* cell instance sky130_fd_sc_hd__fill_8_129 r0 *1 0,0
Xsky130_fd_sc_hd__fill_8_129 VSS VDD VDD sky130_fd_sc_hd__fill_8
* cell instance sky130_fd_sc_hd__fill_8_130 r0 *1 0,0
Xsky130_fd_sc_hd__fill_8_130 VSS VDD VDD sky130_fd_sc_hd__fill_8
* cell instance sky130_fd_sc_hd__fill_8_131 r0 *1 0,0
Xsky130_fd_sc_hd__fill_8_131 VSS VDD VDD sky130_fd_sc_hd__fill_8
* cell instance sky130_fd_sc_hd__fill_8_132 r0 *1 0,0
Xsky130_fd_sc_hd__fill_8_132 VSS VDD VDD sky130_fd_sc_hd__fill_8
* cell instance sky130_fd_sc_hd__fill_8_133 r0 *1 0,0
Xsky130_fd_sc_hd__fill_8_133 VSS VDD VDD sky130_fd_sc_hd__fill_8
* cell instance sky130_fd_sc_hd__fill_8_134 r0 *1 0,0
Xsky130_fd_sc_hd__fill_8_134 VSS VDD VDD sky130_fd_sc_hd__fill_8
* cell instance sky130_fd_sc_hd__fill_8_135 r0 *1 0,0
Xsky130_fd_sc_hd__fill_8_135 VSS VDD VDD sky130_fd_sc_hd__fill_8
* cell instance sky130_fd_sc_hd__fill_8_136 r0 *1 0,0
Xsky130_fd_sc_hd__fill_8_136 VSS VDD VDD sky130_fd_sc_hd__fill_8
* cell instance sky130_fd_sc_hd__fill_8_137 r0 *1 0,0
Xsky130_fd_sc_hd__fill_8_137 VSS VDD VDD sky130_fd_sc_hd__fill_8
* cell instance sky130_fd_sc_hd__fill_8_138 r0 *1 0,0
Xsky130_fd_sc_hd__fill_8_138 VSS VDD VDD sky130_fd_sc_hd__fill_8
* cell instance sky130_fd_sc_hd__fill_8_139 r0 *1 0,0
Xsky130_fd_sc_hd__fill_8_139 VSS VDD VDD sky130_fd_sc_hd__fill_8
* cell instance sky130_fd_sc_hd__fill_8_140 r0 *1 0,0
Xsky130_fd_sc_hd__fill_8_140 VSS VDD VDD sky130_fd_sc_hd__fill_8
* cell instance sky130_fd_sc_hd__fill_8_141 r0 *1 0,0
Xsky130_fd_sc_hd__fill_8_141 VSS VDD VDD sky130_fd_sc_hd__fill_8
* cell instance sky130_fd_sc_hd__fill_8_142 r0 *1 0,0
Xsky130_fd_sc_hd__fill_8_142 VSS VDD VDD sky130_fd_sc_hd__fill_8
* cell instance sky130_fd_sc_hd__fill_8_143 r0 *1 0,0
Xsky130_fd_sc_hd__fill_8_143 VSS VDD VDD sky130_fd_sc_hd__fill_8
* cell instance sky130_fd_sc_hd__fill_8_144 r0 *1 0,0
Xsky130_fd_sc_hd__fill_8_144 VSS VDD VDD sky130_fd_sc_hd__fill_8
* cell instance sky130_fd_sc_hd__fill_8_145 r0 *1 0,0
Xsky130_fd_sc_hd__fill_8_145 VSS VDD VDD sky130_fd_sc_hd__fill_8
* cell instance sky130_fd_sc_hd__fill_8_146 r0 *1 0,0
Xsky130_fd_sc_hd__fill_8_146 VSS VDD VDD sky130_fd_sc_hd__fill_8
* cell instance sky130_fd_sc_hd__fill_8_147 r0 *1 0,0
Xsky130_fd_sc_hd__fill_8_147 VSS VDD VDD sky130_fd_sc_hd__fill_8
* cell instance sky130_fd_sc_hd__fill_8_148 r0 *1 0,0
Xsky130_fd_sc_hd__fill_8_148 VSS VDD VDD sky130_fd_sc_hd__fill_8
* cell instance sky130_fd_sc_hd__fill_8_149 r0 *1 0,0
Xsky130_fd_sc_hd__fill_8_149 VSS VDD VDD sky130_fd_sc_hd__fill_8
* cell instance sky130_fd_sc_hd__fill_8_150 r0 *1 0,0
Xsky130_fd_sc_hd__fill_8_150 VSS VDD VDD sky130_fd_sc_hd__fill_8
* cell instance sky130_fd_sc_hd__fill_8_151 r0 *1 0,0
Xsky130_fd_sc_hd__fill_8_151 VSS VDD VDD sky130_fd_sc_hd__fill_8
* cell instance sky130_fd_sc_hd__fill_8_152 r0 *1 0,0
Xsky130_fd_sc_hd__fill_8_152 VSS VDD VDD sky130_fd_sc_hd__fill_8
* cell instance sky130_fd_sc_hd__fill_8_153 r0 *1 0,0
Xsky130_fd_sc_hd__fill_8_153 VSS VDD VDD sky130_fd_sc_hd__fill_8
* cell instance sky130_fd_sc_hd__fill_8_154 r0 *1 0,0
Xsky130_fd_sc_hd__fill_8_154 VSS VDD VDD sky130_fd_sc_hd__fill_8
* cell instance sky130_fd_sc_hd__fill_8_155 r0 *1 0,0
Xsky130_fd_sc_hd__fill_8_155 VSS VDD VDD sky130_fd_sc_hd__fill_8
* cell instance sky130_fd_sc_hd__fill_8_156 r0 *1 0,0
Xsky130_fd_sc_hd__fill_8_156 VSS VDD VDD sky130_fd_sc_hd__fill_8
* cell instance sky130_fd_sc_hd__fill_8_157 r0 *1 0,0
Xsky130_fd_sc_hd__fill_8_157 VSS VDD VDD sky130_fd_sc_hd__fill_8
* cell instance sky130_fd_sc_hd__fill_8_158 r0 *1 0,0
Xsky130_fd_sc_hd__fill_8_158 VSS VDD VDD sky130_fd_sc_hd__fill_8
* cell instance sky130_fd_sc_hd__fill_8_159 r0 *1 0,0
Xsky130_fd_sc_hd__fill_8_159 VSS VDD VDD sky130_fd_sc_hd__fill_8
* cell instance sky130_fd_sc_hd__fill_8_160 r0 *1 0,0
Xsky130_fd_sc_hd__fill_8_160 VSS VDD VDD sky130_fd_sc_hd__fill_8
* cell instance sky130_fd_sc_hd__fill_8_161 r0 *1 0,0
Xsky130_fd_sc_hd__fill_8_161 VSS VDD VDD sky130_fd_sc_hd__fill_8
* cell instance sky130_fd_sc_hd__fill_8_162 r0 *1 0,0
Xsky130_fd_sc_hd__fill_8_162 VSS VDD VDD sky130_fd_sc_hd__fill_8
* cell instance sky130_fd_sc_hd__fill_8_163 r0 *1 0,0
Xsky130_fd_sc_hd__fill_8_163 VSS VDD VDD sky130_fd_sc_hd__fill_8
* cell instance sky130_fd_sc_hd__fill_8_164 r0 *1 0,0
Xsky130_fd_sc_hd__fill_8_164 VSS VDD VDD sky130_fd_sc_hd__fill_8
* cell instance sky130_fd_sc_hd__fill_8_165 r0 *1 0,0
Xsky130_fd_sc_hd__fill_8_165 VSS VDD VDD sky130_fd_sc_hd__fill_8
* cell instance sky130_fd_sc_hd__fill_8_166 r0 *1 0,0
Xsky130_fd_sc_hd__fill_8_166 VSS VDD VDD sky130_fd_sc_hd__fill_8
* cell instance sky130_fd_sc_hd__fill_8_167 r0 *1 0,0
Xsky130_fd_sc_hd__fill_8_167 VSS VDD VDD sky130_fd_sc_hd__fill_8
* cell instance sky130_fd_sc_hd__fill_8_168 r0 *1 0,0
Xsky130_fd_sc_hd__fill_8_168 VSS VDD VDD sky130_fd_sc_hd__fill_8
* cell instance sky130_fd_sc_hd__fill_8_169 r0 *1 0,0
Xsky130_fd_sc_hd__fill_8_169 VSS VDD VDD sky130_fd_sc_hd__fill_8
* cell instance sky130_fd_sc_hd__fill_8_170 r0 *1 0,0
Xsky130_fd_sc_hd__fill_8_170 VSS VDD VDD sky130_fd_sc_hd__fill_8
* cell instance sky130_fd_sc_hd__fill_8_171 r0 *1 0,0
Xsky130_fd_sc_hd__fill_8_171 VSS VDD VDD sky130_fd_sc_hd__fill_8
* cell instance sky130_fd_sc_hd__fill_8_172 r0 *1 0,0
Xsky130_fd_sc_hd__fill_8_172 VSS VDD VDD sky130_fd_sc_hd__fill_8
* cell instance sky130_fd_sc_hd__fill_8_173 r0 *1 0,0
Xsky130_fd_sc_hd__fill_8_173 VSS VDD VDD sky130_fd_sc_hd__fill_8
* cell instance sky130_fd_sc_hd__fill_8_174 r0 *1 0,0
Xsky130_fd_sc_hd__fill_8_174 VSS VDD VDD sky130_fd_sc_hd__fill_8
* cell instance sky130_fd_sc_hd__fill_8_175 r0 *1 0,0
Xsky130_fd_sc_hd__fill_8_175 VSS VDD VDD sky130_fd_sc_hd__fill_8
* cell instance sky130_fd_sc_hd__fill_8_176 r0 *1 0,0
Xsky130_fd_sc_hd__fill_8_176 VSS VDD VDD sky130_fd_sc_hd__fill_8
* cell instance sky130_fd_sc_hd__fill_8_177 r0 *1 0,0
Xsky130_fd_sc_hd__fill_8_177 VSS VDD VDD sky130_fd_sc_hd__fill_8
* cell instance sky130_fd_sc_hd__fill_8_178 r0 *1 0,0
Xsky130_fd_sc_hd__fill_8_178 VSS VDD VDD sky130_fd_sc_hd__fill_8
* cell instance sky130_fd_sc_hd__fill_8_179 r0 *1 0,0
Xsky130_fd_sc_hd__fill_8_179 VSS VDD VDD sky130_fd_sc_hd__fill_8
* cell instance sky130_fd_sc_hd__fill_8_180 r0 *1 0,0
Xsky130_fd_sc_hd__fill_8_180 VSS VDD VDD sky130_fd_sc_hd__fill_8
* cell instance sky130_fd_sc_hd__fill_8_181 r0 *1 0,0
Xsky130_fd_sc_hd__fill_8_181 VSS VDD VDD sky130_fd_sc_hd__fill_8
* cell instance sky130_fd_sc_hd__fill_8_182 r0 *1 0,0
Xsky130_fd_sc_hd__fill_8_182 VSS VDD VDD sky130_fd_sc_hd__fill_8
* cell instance sky130_fd_sc_hd__fill_8_183 r0 *1 0,0
Xsky130_fd_sc_hd__fill_8_183 VSS VDD VDD sky130_fd_sc_hd__fill_8
* cell instance sky130_fd_sc_hd__fill_8_184 r0 *1 0,0
Xsky130_fd_sc_hd__fill_8_184 VSS VDD VDD sky130_fd_sc_hd__fill_8
* cell instance sky130_fd_sc_hd__fill_8_185 r0 *1 0,0
Xsky130_fd_sc_hd__fill_8_185 VSS VDD VDD sky130_fd_sc_hd__fill_8
* cell instance sky130_fd_sc_hd__fill_8_186 r0 *1 0,0
Xsky130_fd_sc_hd__fill_8_186 VSS VDD VDD sky130_fd_sc_hd__fill_8
* cell instance sky130_fd_sc_hd__fill_8_187 r0 *1 0,0
Xsky130_fd_sc_hd__fill_8_187 VSS VDD VDD sky130_fd_sc_hd__fill_8
* cell instance sky130_fd_sc_hd__fill_8_188 r0 *1 0,0
Xsky130_fd_sc_hd__fill_8_188 VSS VDD VDD sky130_fd_sc_hd__fill_8
* cell instance sky130_fd_sc_hd__fill_8_189 r0 *1 0,0
Xsky130_fd_sc_hd__fill_8_189 VSS VDD VDD sky130_fd_sc_hd__fill_8
* cell instance sky130_fd_sc_hd__fill_8_190 r0 *1 0,0
Xsky130_fd_sc_hd__fill_8_190 VSS VDD VDD sky130_fd_sc_hd__fill_8
* cell instance sky130_fd_sc_hd__fill_8_191 r0 *1 0,0
Xsky130_fd_sc_hd__fill_8_191 VSS VDD VDD sky130_fd_sc_hd__fill_8
* cell instance sky130_fd_sc_hd__fill_8_192 r0 *1 0,0
Xsky130_fd_sc_hd__fill_8_192 VSS VDD VDD sky130_fd_sc_hd__fill_8
* cell instance sky130_fd_sc_hd__fill_8_193 r0 *1 0,0
Xsky130_fd_sc_hd__fill_8_193 VSS VDD VDD sky130_fd_sc_hd__fill_8
* cell instance sky130_fd_sc_hd__fill_8_194 r0 *1 0,0
Xsky130_fd_sc_hd__fill_8_194 VSS VDD VDD sky130_fd_sc_hd__fill_8
* cell instance sky130_fd_sc_hd__fill_8_195 r0 *1 0,0
Xsky130_fd_sc_hd__fill_8_195 VSS VDD VDD sky130_fd_sc_hd__fill_8
* cell instance sky130_fd_sc_hd__fill_8_196 r0 *1 0,0
Xsky130_fd_sc_hd__fill_8_196 VSS VDD VDD sky130_fd_sc_hd__fill_8
* cell instance sky130_fd_sc_hd__fill_8_197 r0 *1 0,0
Xsky130_fd_sc_hd__fill_8_197 VSS VDD VDD sky130_fd_sc_hd__fill_8
* cell instance sky130_fd_sc_hd__fill_8_198 r0 *1 0,0
Xsky130_fd_sc_hd__fill_8_198 VSS VDD VDD sky130_fd_sc_hd__fill_8
* cell instance sky130_fd_sc_hd__fill_8_199 r0 *1 0,0
Xsky130_fd_sc_hd__fill_8_199 VSS VDD VDD sky130_fd_sc_hd__fill_8
* cell instance sky130_fd_sc_hd__fill_8_200 r0 *1 0,0
Xsky130_fd_sc_hd__fill_8_200 VSS VDD VDD sky130_fd_sc_hd__fill_8
* cell instance sky130_fd_sc_hd__fill_8_201 r0 *1 0,0
Xsky130_fd_sc_hd__fill_8_201 VSS VDD VDD sky130_fd_sc_hd__fill_8
* cell instance sky130_fd_sc_hd__fill_8_202 r0 *1 0,0
Xsky130_fd_sc_hd__fill_8_202 VSS VDD VDD sky130_fd_sc_hd__fill_8
* cell instance sky130_fd_sc_hd__fill_8_203 r0 *1 0,0
Xsky130_fd_sc_hd__fill_8_203 VSS VDD VDD sky130_fd_sc_hd__fill_8
* cell instance sky130_fd_sc_hd__fill_8_204 r0 *1 0,0
Xsky130_fd_sc_hd__fill_8_204 VSS VDD VDD sky130_fd_sc_hd__fill_8
* cell instance sky130_fd_sc_hd__fill_8_205 r0 *1 0,0
Xsky130_fd_sc_hd__fill_8_205 VSS VDD VDD sky130_fd_sc_hd__fill_8
* cell instance sky130_fd_sc_hd__fill_8_206 r0 *1 0,0
Xsky130_fd_sc_hd__fill_8_206 VSS VDD VDD sky130_fd_sc_hd__fill_8
* cell instance sky130_fd_sc_hd__fill_8_207 r0 *1 0,0
Xsky130_fd_sc_hd__fill_8_207 VSS VDD VDD sky130_fd_sc_hd__fill_8
* cell instance sky130_fd_sc_hd__fill_8_208 r0 *1 0,0
Xsky130_fd_sc_hd__fill_8_208 VSS VDD VDD sky130_fd_sc_hd__fill_8
* cell instance sky130_fd_sc_hd__fill_8_209 r0 *1 0,0
Xsky130_fd_sc_hd__fill_8_209 VSS VDD VDD sky130_fd_sc_hd__fill_8
* cell instance sky130_fd_sc_hd__fill_8_210 r0 *1 0,0
Xsky130_fd_sc_hd__fill_8_210 VSS VDD VDD sky130_fd_sc_hd__fill_8
* cell instance sky130_fd_sc_hd__fill_8_211 r0 *1 0,0
Xsky130_fd_sc_hd__fill_8_211 VSS VDD VDD sky130_fd_sc_hd__fill_8
* cell instance sky130_fd_sc_hd__fill_8_212 r0 *1 0,0
Xsky130_fd_sc_hd__fill_8_212 VSS VDD VDD sky130_fd_sc_hd__fill_8
* cell instance sky130_fd_sc_hd__fill_8_213 r0 *1 0,0
Xsky130_fd_sc_hd__fill_8_213 VSS VDD VDD sky130_fd_sc_hd__fill_8
* cell instance sky130_fd_sc_hd__fill_8_214 r0 *1 0,0
Xsky130_fd_sc_hd__fill_8_214 VSS VDD VDD sky130_fd_sc_hd__fill_8
* cell instance sky130_fd_sc_hd__fill_8_215 r0 *1 0,0
Xsky130_fd_sc_hd__fill_8_215 VSS VDD VDD sky130_fd_sc_hd__fill_8
* cell instance sky130_fd_sc_hd__fill_8_216 r0 *1 0,0
Xsky130_fd_sc_hd__fill_8_216 VSS VDD VDD sky130_fd_sc_hd__fill_8
* cell instance sky130_fd_sc_hd__fill_8_217 r0 *1 0,0
Xsky130_fd_sc_hd__fill_8_217 VSS VDD VDD sky130_fd_sc_hd__fill_8
* cell instance sky130_fd_sc_hd__fill_8_218 r0 *1 0,0
Xsky130_fd_sc_hd__fill_8_218 VSS VDD VDD sky130_fd_sc_hd__fill_8
* cell instance sky130_fd_sc_hd__fill_8_219 r0 *1 0,0
Xsky130_fd_sc_hd__fill_8_219 VSS VDD VDD sky130_fd_sc_hd__fill_8
* cell instance sky130_fd_sc_hd__fill_8_220 r0 *1 0,0
Xsky130_fd_sc_hd__fill_8_220 VSS VDD VDD sky130_fd_sc_hd__fill_8
* cell instance sky130_fd_sc_hd__fill_8_221 r0 *1 0,0
Xsky130_fd_sc_hd__fill_8_221 VSS VDD VDD sky130_fd_sc_hd__fill_8
* cell instance sky130_fd_sc_hd__fill_8_222 r0 *1 0,0
Xsky130_fd_sc_hd__fill_8_222 VSS VDD VDD sky130_fd_sc_hd__fill_8
* cell instance sky130_fd_sc_hd__fill_8_223 r0 *1 0,0
Xsky130_fd_sc_hd__fill_8_223 VSS VDD VDD sky130_fd_sc_hd__fill_8
* cell instance sky130_fd_sc_hd__fill_8_224 r0 *1 0,0
Xsky130_fd_sc_hd__fill_8_224 VSS VDD VDD sky130_fd_sc_hd__fill_8
* cell instance sky130_fd_sc_hd__fill_8_225 r0 *1 0,0
Xsky130_fd_sc_hd__fill_8_225 VSS VDD VDD sky130_fd_sc_hd__fill_8
* cell instance sky130_fd_sc_hd__fill_8_226 r0 *1 0,0
Xsky130_fd_sc_hd__fill_8_226 VSS VDD VDD sky130_fd_sc_hd__fill_8
* cell instance sky130_fd_sc_hd__fill_8_227 r0 *1 0,0
Xsky130_fd_sc_hd__fill_8_227 VSS VDD VDD sky130_fd_sc_hd__fill_8
* cell instance sky130_fd_sc_hd__fill_8_228 r0 *1 0,0
Xsky130_fd_sc_hd__fill_8_228 VSS VDD VDD sky130_fd_sc_hd__fill_8
* cell instance sky130_fd_sc_hd__fill_8_229 r0 *1 0,0
Xsky130_fd_sc_hd__fill_8_229 VSS VDD VDD sky130_fd_sc_hd__fill_8
* cell instance sky130_fd_sc_hd__fill_8_230 r0 *1 0,0
Xsky130_fd_sc_hd__fill_8_230 VSS VDD VDD sky130_fd_sc_hd__fill_8
* cell instance sky130_fd_sc_hd__fill_8_231 r0 *1 0,0
Xsky130_fd_sc_hd__fill_8_231 VSS VDD VDD sky130_fd_sc_hd__fill_8
* cell instance sky130_fd_sc_hd__fill_8_232 r0 *1 0,0
Xsky130_fd_sc_hd__fill_8_232 VSS VDD VDD sky130_fd_sc_hd__fill_8
* cell instance sky130_fd_sc_hd__fill_8_233 r0 *1 0,0
Xsky130_fd_sc_hd__fill_8_233 VSS VDD VDD sky130_fd_sc_hd__fill_8
* cell instance sky130_fd_sc_hd__fill_8_234 r0 *1 0,0
Xsky130_fd_sc_hd__fill_8_234 VSS VDD VDD sky130_fd_sc_hd__fill_8
* cell instance sky130_fd_sc_hd__fill_8_235 r0 *1 0,0
Xsky130_fd_sc_hd__fill_8_235 VSS VDD VDD sky130_fd_sc_hd__fill_8
* cell instance sky130_fd_sc_hd__fill_8_236 r0 *1 0,0
Xsky130_fd_sc_hd__fill_8_236 VSS VDD VDD sky130_fd_sc_hd__fill_8
* cell instance sky130_fd_sc_hd__fill_8_237 r0 *1 0,0
Xsky130_fd_sc_hd__fill_8_237 VSS VDD VDD sky130_fd_sc_hd__fill_8
* cell instance sky130_fd_sc_hd__fill_8_238 r0 *1 0,0
Xsky130_fd_sc_hd__fill_8_238 VSS VDD VDD sky130_fd_sc_hd__fill_8
* cell instance sky130_fd_sc_hd__fill_8_239 r0 *1 0,0
Xsky130_fd_sc_hd__fill_8_239 VSS VDD VDD sky130_fd_sc_hd__fill_8
* cell instance sky130_fd_sc_hd__fill_8_240 r0 *1 0,0
Xsky130_fd_sc_hd__fill_8_240 VSS VDD VDD sky130_fd_sc_hd__fill_8
* cell instance sky130_fd_sc_hd__fill_8_241 r0 *1 0,0
Xsky130_fd_sc_hd__fill_8_241 VSS VDD VDD sky130_fd_sc_hd__fill_8
* cell instance sky130_fd_sc_hd__fill_8_242 r0 *1 0,0
Xsky130_fd_sc_hd__fill_8_242 VSS VDD VDD sky130_fd_sc_hd__fill_8
* cell instance sky130_fd_sc_hd__fill_8_243 r0 *1 0,0
Xsky130_fd_sc_hd__fill_8_243 VSS VDD VDD sky130_fd_sc_hd__fill_8
* cell instance sky130_fd_sc_hd__fill_8_244 r0 *1 0,0
Xsky130_fd_sc_hd__fill_8_244 VSS VDD VDD sky130_fd_sc_hd__fill_8
* cell instance sky130_fd_sc_hd__fill_8_245 r0 *1 0,0
Xsky130_fd_sc_hd__fill_8_245 VSS VDD VDD sky130_fd_sc_hd__fill_8
* cell instance sky130_fd_sc_hd__fill_8_246 r0 *1 0,0
Xsky130_fd_sc_hd__fill_8_246 VSS VDD VDD sky130_fd_sc_hd__fill_8
* cell instance sky130_fd_sc_hd__fill_8_247 r0 *1 0,0
Xsky130_fd_sc_hd__fill_8_247 VSS VDD VDD sky130_fd_sc_hd__fill_8
* cell instance sky130_fd_sc_hd__fill_8_248 r0 *1 0,0
Xsky130_fd_sc_hd__fill_8_248 VSS VDD VDD sky130_fd_sc_hd__fill_8
* cell instance sky130_fd_sc_hd__fill_8_249 r0 *1 0,0
Xsky130_fd_sc_hd__fill_8_249 VSS VDD VDD sky130_fd_sc_hd__fill_8
* cell instance sky130_fd_sc_hd__fill_8_250 r0 *1 0,0
Xsky130_fd_sc_hd__fill_8_250 VSS VDD VDD sky130_fd_sc_hd__fill_8
* cell instance sky130_fd_sc_hd__fill_8_251 r0 *1 0,0
Xsky130_fd_sc_hd__fill_8_251 VSS VDD VDD sky130_fd_sc_hd__fill_8
* cell instance sky130_fd_sc_hd__fill_8_252 r0 *1 0,0
Xsky130_fd_sc_hd__fill_8_252 VSS VDD VDD sky130_fd_sc_hd__fill_8
* cell instance sky130_fd_sc_hd__fill_8_253 r0 *1 0,0
Xsky130_fd_sc_hd__fill_8_253 VSS VDD VDD sky130_fd_sc_hd__fill_8
* cell instance sky130_fd_sc_hd__fill_8_254 r0 *1 0,0
Xsky130_fd_sc_hd__fill_8_254 VSS VDD VDD sky130_fd_sc_hd__fill_8
* cell instance sky130_fd_sc_hd__fill_8_255 r0 *1 0,0
Xsky130_fd_sc_hd__fill_8_255 VSS VDD VDD sky130_fd_sc_hd__fill_8
* cell instance sky130_fd_sc_hd__fill_8_256 r0 *1 0,0
Xsky130_fd_sc_hd__fill_8_256 VSS VDD VDD sky130_fd_sc_hd__fill_8
* cell instance sky130_fd_sc_hd__fill_8_257 r0 *1 0,0
Xsky130_fd_sc_hd__fill_8_257 VSS VDD VDD sky130_fd_sc_hd__fill_8
* cell instance sky130_fd_sc_hd__fill_8_258 r0 *1 0,0
Xsky130_fd_sc_hd__fill_8_258 VSS VDD VDD sky130_fd_sc_hd__fill_8
* cell instance sky130_fd_sc_hd__fill_8_259 r0 *1 0,0
Xsky130_fd_sc_hd__fill_8_259 VSS VDD VDD sky130_fd_sc_hd__fill_8
* cell instance sky130_fd_sc_hd__fill_8_260 r0 *1 0,0
Xsky130_fd_sc_hd__fill_8_260 VSS VDD VDD sky130_fd_sc_hd__fill_8
* cell instance sky130_fd_sc_hd__fill_8_261 r0 *1 0,0
Xsky130_fd_sc_hd__fill_8_261 VSS VDD VDD sky130_fd_sc_hd__fill_8
* cell instance sky130_fd_sc_hd__fill_8_262 r0 *1 0,0
Xsky130_fd_sc_hd__fill_8_262 VSS VDD VDD sky130_fd_sc_hd__fill_8
* cell instance sky130_fd_sc_hd__fill_8_263 r0 *1 0,0
Xsky130_fd_sc_hd__fill_8_263 VSS VDD VDD sky130_fd_sc_hd__fill_8
* cell instance sky130_fd_sc_hd__fill_8_264 r0 *1 0,0
Xsky130_fd_sc_hd__fill_8_264 VSS VDD VDD sky130_fd_sc_hd__fill_8
* cell instance sky130_fd_sc_hd__fill_8_265 r0 *1 0,0
Xsky130_fd_sc_hd__fill_8_265 VSS VDD VDD sky130_fd_sc_hd__fill_8
* cell instance sky130_fd_sc_hd__fill_8_266 r0 *1 0,0
Xsky130_fd_sc_hd__fill_8_266 VSS VDD VDD sky130_fd_sc_hd__fill_8
* cell instance sky130_fd_sc_hd__fill_8_267 r0 *1 0,0
Xsky130_fd_sc_hd__fill_8_267 VSS VDD VDD sky130_fd_sc_hd__fill_8
* cell instance sky130_fd_sc_hd__fill_8_268 r0 *1 0,0
Xsky130_fd_sc_hd__fill_8_268 VSS VDD VDD sky130_fd_sc_hd__fill_8
* cell instance sky130_fd_sc_hd__fill_8_269 r0 *1 0,0
Xsky130_fd_sc_hd__fill_8_269 VSS VDD VDD sky130_fd_sc_hd__fill_8
* cell instance sky130_fd_sc_hd__fill_8_270 r0 *1 0,0
Xsky130_fd_sc_hd__fill_8_270 VSS VDD VDD sky130_fd_sc_hd__fill_8
* cell instance sky130_fd_sc_hd__fill_8_271 r0 *1 0,0
Xsky130_fd_sc_hd__fill_8_271 VSS VDD VDD sky130_fd_sc_hd__fill_8
* cell instance sky130_fd_sc_hd__fill_8_272 r0 *1 0,0
Xsky130_fd_sc_hd__fill_8_272 VSS VDD VDD sky130_fd_sc_hd__fill_8
* cell instance sky130_fd_sc_hd__fill_8_273 r0 *1 0,0
Xsky130_fd_sc_hd__fill_8_273 VSS VDD VDD sky130_fd_sc_hd__fill_8
* cell instance sky130_fd_sc_hd__fill_8_274 r0 *1 0,0
Xsky130_fd_sc_hd__fill_8_274 VSS VDD VDD sky130_fd_sc_hd__fill_8
* cell instance sky130_fd_sc_hd__fill_8_275 r0 *1 0,0
Xsky130_fd_sc_hd__fill_8_275 VSS VDD VDD sky130_fd_sc_hd__fill_8
* cell instance sky130_fd_sc_hd__fill_8_276 r0 *1 0,0
Xsky130_fd_sc_hd__fill_8_276 VSS VDD VDD sky130_fd_sc_hd__fill_8
* cell instance sky130_fd_sc_hd__fill_8_277 r0 *1 0,0
Xsky130_fd_sc_hd__fill_8_277 VSS VDD VDD sky130_fd_sc_hd__fill_8
* cell instance sky130_fd_sc_hd__fill_8_278 r0 *1 0,0
Xsky130_fd_sc_hd__fill_8_278 VSS VDD VDD sky130_fd_sc_hd__fill_8
* cell instance sky130_fd_sc_hd__fill_8_279 r0 *1 0,0
Xsky130_fd_sc_hd__fill_8_279 VSS VDD VDD sky130_fd_sc_hd__fill_8
* cell instance sky130_fd_sc_hd__fill_8_280 r0 *1 0,0
Xsky130_fd_sc_hd__fill_8_280 VSS VDD VDD sky130_fd_sc_hd__fill_8
* cell instance sky130_fd_sc_hd__fill_8_281 r0 *1 0,0
Xsky130_fd_sc_hd__fill_8_281 VSS VDD VDD sky130_fd_sc_hd__fill_8
* cell instance sky130_fd_sc_hd__fill_8_282 r0 *1 0,0
Xsky130_fd_sc_hd__fill_8_282 VSS VDD VDD sky130_fd_sc_hd__fill_8
* cell instance sky130_fd_sc_hd__fill_8_283 r0 *1 0,0
Xsky130_fd_sc_hd__fill_8_283 VSS VDD VDD sky130_fd_sc_hd__fill_8
* cell instance sky130_fd_sc_hd__fill_8_284 r0 *1 0,0
Xsky130_fd_sc_hd__fill_8_284 VSS VDD VDD sky130_fd_sc_hd__fill_8
* cell instance sky130_fd_sc_hd__fill_8_285 r0 *1 0,0
Xsky130_fd_sc_hd__fill_8_285 VSS VDD VDD sky130_fd_sc_hd__fill_8
* cell instance sky130_fd_sc_hd__fill_8_286 r0 *1 0,0
Xsky130_fd_sc_hd__fill_8_286 VSS VDD VDD sky130_fd_sc_hd__fill_8
* cell instance sky130_fd_sc_hd__fill_8_287 r0 *1 0,0
Xsky130_fd_sc_hd__fill_8_287 VSS VDD VDD sky130_fd_sc_hd__fill_8
* cell instance sky130_fd_sc_hd__fill_8_288 r0 *1 0,0
Xsky130_fd_sc_hd__fill_8_288 VSS VDD VDD sky130_fd_sc_hd__fill_8
* cell instance sky130_fd_sc_hd__fill_8_289 r0 *1 0,0
Xsky130_fd_sc_hd__fill_8_289 VSS VDD VDD sky130_fd_sc_hd__fill_8
* cell instance sky130_fd_sc_hd__fill_8_290 r0 *1 0,0
Xsky130_fd_sc_hd__fill_8_290 VSS VDD VDD sky130_fd_sc_hd__fill_8
* cell instance sky130_fd_sc_hd__fill_8_291 r0 *1 0,0
Xsky130_fd_sc_hd__fill_8_291 VSS VDD VDD sky130_fd_sc_hd__fill_8
* cell instance sky130_fd_sc_hd__fill_8_292 r0 *1 0,0
Xsky130_fd_sc_hd__fill_8_292 VSS VDD VDD sky130_fd_sc_hd__fill_8
* cell instance sky130_fd_sc_hd__fill_8_293 r0 *1 0,0
Xsky130_fd_sc_hd__fill_8_293 VSS VDD VDD sky130_fd_sc_hd__fill_8
* cell instance sky130_fd_sc_hd__fill_8_294 r0 *1 0,0
Xsky130_fd_sc_hd__fill_8_294 VSS VDD VDD sky130_fd_sc_hd__fill_8
* cell instance sky130_fd_sc_hd__fill_8_295 r0 *1 0,0
Xsky130_fd_sc_hd__fill_8_295 VSS VDD VDD sky130_fd_sc_hd__fill_8
* cell instance sky130_fd_sc_hd__fill_8_296 r0 *1 0,0
Xsky130_fd_sc_hd__fill_8_296 VSS VDD VDD sky130_fd_sc_hd__fill_8
* cell instance sky130_fd_sc_hd__fill_8_297 r0 *1 0,0
Xsky130_fd_sc_hd__fill_8_297 VSS VDD VDD sky130_fd_sc_hd__fill_8
* cell instance sky130_fd_sc_hd__fill_8_298 r0 *1 0,0
Xsky130_fd_sc_hd__fill_8_298 VSS VDD VDD sky130_fd_sc_hd__fill_8
* cell instance sky130_fd_sc_hd__fill_8_299 r0 *1 0,0
Xsky130_fd_sc_hd__fill_8_299 VSS VDD VDD sky130_fd_sc_hd__fill_8
* cell instance sky130_fd_sc_hd__fill_8_300 r0 *1 0,0
Xsky130_fd_sc_hd__fill_8_300 VSS VDD VDD sky130_fd_sc_hd__fill_8
* cell instance sky130_fd_sc_hd__fill_8_301 r0 *1 0,0
Xsky130_fd_sc_hd__fill_8_301 VSS VDD VDD sky130_fd_sc_hd__fill_8
* cell instance sky130_fd_sc_hd__fill_8_302 r0 *1 0,0
Xsky130_fd_sc_hd__fill_8_302 VSS VDD VDD sky130_fd_sc_hd__fill_8
* cell instance sky130_fd_sc_hd__fill_8_303 r0 *1 0,0
Xsky130_fd_sc_hd__fill_8_303 VSS VDD VDD sky130_fd_sc_hd__fill_8
* cell instance sky130_fd_sc_hd__fill_8_304 r0 *1 0,0
Xsky130_fd_sc_hd__fill_8_304 VSS VDD VDD sky130_fd_sc_hd__fill_8
* cell instance sky130_fd_sc_hd__fill_8_305 r0 *1 0,0
Xsky130_fd_sc_hd__fill_8_305 VSS VDD VDD sky130_fd_sc_hd__fill_8
* cell instance sky130_fd_sc_hd__fill_8_306 r0 *1 0,0
Xsky130_fd_sc_hd__fill_8_306 VSS VDD VDD sky130_fd_sc_hd__fill_8
* cell instance sky130_fd_sc_hd__fill_8_307 r0 *1 0,0
Xsky130_fd_sc_hd__fill_8_307 VSS VDD VDD sky130_fd_sc_hd__fill_8
* cell instance sky130_fd_sc_hd__fill_8_308 r0 *1 0,0
Xsky130_fd_sc_hd__fill_8_308 VSS VDD VDD sky130_fd_sc_hd__fill_8
* cell instance sky130_fd_sc_hd__fill_8_309 r0 *1 0,0
Xsky130_fd_sc_hd__fill_8_309 VSS VDD VDD sky130_fd_sc_hd__fill_8
* cell instance sky130_fd_sc_hd__fill_8_310 r0 *1 0,0
Xsky130_fd_sc_hd__fill_8_310 VSS VDD VDD sky130_fd_sc_hd__fill_8
* cell instance sky130_fd_sc_hd__fill_8_311 r0 *1 0,0
Xsky130_fd_sc_hd__fill_8_311 VSS VDD VDD sky130_fd_sc_hd__fill_8
* cell instance sky130_fd_sc_hd__fill_8_312 r0 *1 0,0
Xsky130_fd_sc_hd__fill_8_312 VSS VDD VDD sky130_fd_sc_hd__fill_8
* cell instance sky130_fd_sc_hd__fill_8_313 r0 *1 0,0
Xsky130_fd_sc_hd__fill_8_313 VSS VDD VDD sky130_fd_sc_hd__fill_8
* cell instance sky130_fd_sc_hd__fill_8_314 r0 *1 0,0
Xsky130_fd_sc_hd__fill_8_314 VSS VDD VDD sky130_fd_sc_hd__fill_8
* cell instance sky130_fd_sc_hd__fill_8_315 r0 *1 0,0
Xsky130_fd_sc_hd__fill_8_315 VSS VDD VDD sky130_fd_sc_hd__fill_8
* cell instance sky130_fd_sc_hd__fill_8_316 r0 *1 0,0
Xsky130_fd_sc_hd__fill_8_316 VSS VDD VDD sky130_fd_sc_hd__fill_8
* cell instance sky130_fd_sc_hd__fill_8_317 r0 *1 0,0
Xsky130_fd_sc_hd__fill_8_317 VSS VDD VDD sky130_fd_sc_hd__fill_8
* cell instance sky130_fd_sc_hd__fill_8_318 r0 *1 0,0
Xsky130_fd_sc_hd__fill_8_318 VSS VDD VDD sky130_fd_sc_hd__fill_8
* cell instance sky130_fd_sc_hd__fill_8_319 r0 *1 0,0
Xsky130_fd_sc_hd__fill_8_319 VSS VDD VDD sky130_fd_sc_hd__fill_8
* cell instance sky130_fd_sc_hd__fill_8_320 r0 *1 0,0
Xsky130_fd_sc_hd__fill_8_320 VSS VDD VDD sky130_fd_sc_hd__fill_8
* cell instance sky130_fd_sc_hd__fill_8_321 r0 *1 0,0
Xsky130_fd_sc_hd__fill_8_321 VSS VDD VDD sky130_fd_sc_hd__fill_8
* cell instance sky130_fd_sc_hd__fill_8_322 r0 *1 0,0
Xsky130_fd_sc_hd__fill_8_322 VSS VDD VDD sky130_fd_sc_hd__fill_8
* cell instance sky130_fd_sc_hd__fill_8_323 r0 *1 0,0
Xsky130_fd_sc_hd__fill_8_323 VSS VDD VDD sky130_fd_sc_hd__fill_8
* cell instance sky130_fd_sc_hd__fill_8_324 r0 *1 0,0
Xsky130_fd_sc_hd__fill_8_324 VSS VDD VDD sky130_fd_sc_hd__fill_8
* cell instance sky130_fd_sc_hd__fill_8_325 r0 *1 0,0
Xsky130_fd_sc_hd__fill_8_325 VSS VDD VDD sky130_fd_sc_hd__fill_8
* cell instance sky130_fd_sc_hd__fill_8_326 r0 *1 0,0
Xsky130_fd_sc_hd__fill_8_326 VSS VDD VDD sky130_fd_sc_hd__fill_8
* cell instance sky130_fd_sc_hd__fill_8_327 r0 *1 0,0
Xsky130_fd_sc_hd__fill_8_327 VSS VDD VDD sky130_fd_sc_hd__fill_8
* cell instance sky130_fd_sc_hd__fill_8_328 r0 *1 0,0
Xsky130_fd_sc_hd__fill_8_328 VSS VDD VDD sky130_fd_sc_hd__fill_8
* cell instance sky130_fd_sc_hd__fill_8_329 r0 *1 0,0
Xsky130_fd_sc_hd__fill_8_329 VSS VDD VDD sky130_fd_sc_hd__fill_8
* cell instance sky130_fd_sc_hd__fill_8_330 r0 *1 0,0
Xsky130_fd_sc_hd__fill_8_330 VSS VDD VDD sky130_fd_sc_hd__fill_8
* cell instance sky130_fd_sc_hd__fill_8_331 r0 *1 0,0
Xsky130_fd_sc_hd__fill_8_331 VSS VDD VDD sky130_fd_sc_hd__fill_8
* cell instance sky130_fd_sc_hd__fill_8_332 r0 *1 0,0
Xsky130_fd_sc_hd__fill_8_332 VSS VDD VDD sky130_fd_sc_hd__fill_8
* cell instance sky130_fd_sc_hd__fill_8_333 r0 *1 0,0
Xsky130_fd_sc_hd__fill_8_333 VSS VDD VDD sky130_fd_sc_hd__fill_8
* cell instance sky130_fd_sc_hd__fill_8_334 r0 *1 0,0
Xsky130_fd_sc_hd__fill_8_334 VSS VDD VDD sky130_fd_sc_hd__fill_8
* cell instance sky130_fd_sc_hd__fill_8_335 r0 *1 0,0
Xsky130_fd_sc_hd__fill_8_335 VSS VDD VDD sky130_fd_sc_hd__fill_8
* cell instance sky130_fd_sc_hd__fill_8_336 r0 *1 0,0
Xsky130_fd_sc_hd__fill_8_336 VSS VDD VDD sky130_fd_sc_hd__fill_8
* cell instance sky130_fd_sc_hd__fill_8_337 r0 *1 0,0
Xsky130_fd_sc_hd__fill_8_337 VSS VDD VDD sky130_fd_sc_hd__fill_8
* cell instance sky130_fd_sc_hd__fill_8_338 r0 *1 0,0
Xsky130_fd_sc_hd__fill_8_338 VSS VDD VDD sky130_fd_sc_hd__fill_8
* cell instance sky130_fd_sc_hd__fill_8_339 r0 *1 0,0
Xsky130_fd_sc_hd__fill_8_339 VSS VDD VDD sky130_fd_sc_hd__fill_8
* cell instance sky130_fd_sc_hd__fill_8_340 r0 *1 0,0
Xsky130_fd_sc_hd__fill_8_340 VSS VDD VDD sky130_fd_sc_hd__fill_8
* cell instance sky130_fd_sc_hd__fill_8_341 r0 *1 0,0
Xsky130_fd_sc_hd__fill_8_341 VSS VDD VDD sky130_fd_sc_hd__fill_8
* cell instance sky130_fd_sc_hd__fill_8_342 r0 *1 0,0
Xsky130_fd_sc_hd__fill_8_342 VSS VDD VDD sky130_fd_sc_hd__fill_8
* cell instance sky130_fd_sc_hd__fill_8_343 r0 *1 0,0
Xsky130_fd_sc_hd__fill_8_343 VSS VDD VDD sky130_fd_sc_hd__fill_8
* cell instance sky130_fd_sc_hd__fill_8_344 r0 *1 0,0
Xsky130_fd_sc_hd__fill_8_344 VSS VDD VDD sky130_fd_sc_hd__fill_8
* cell instance sky130_fd_sc_hd__fill_8_345 r0 *1 0,0
Xsky130_fd_sc_hd__fill_8_345 VSS VDD VDD sky130_fd_sc_hd__fill_8
* cell instance sky130_fd_sc_hd__fill_8_346 r0 *1 0,0
Xsky130_fd_sc_hd__fill_8_346 VSS VDD VDD sky130_fd_sc_hd__fill_8
* cell instance sky130_fd_sc_hd__fill_8_347 r0 *1 0,0
Xsky130_fd_sc_hd__fill_8_347 VSS VDD VDD sky130_fd_sc_hd__fill_8
* cell instance sky130_fd_sc_hd__fill_8_348 r0 *1 0,0
Xsky130_fd_sc_hd__fill_8_348 VSS VDD VDD sky130_fd_sc_hd__fill_8
* cell instance sky130_fd_sc_hd__fill_8_349 r0 *1 0,0
Xsky130_fd_sc_hd__fill_8_349 VSS VDD VDD sky130_fd_sc_hd__fill_8
* cell instance sky130_fd_sc_hd__fill_8_350 r0 *1 0,0
Xsky130_fd_sc_hd__fill_8_350 VSS VDD VDD sky130_fd_sc_hd__fill_8
* cell instance sky130_fd_sc_hd__fill_8_351 r0 *1 0,0
Xsky130_fd_sc_hd__fill_8_351 VSS VDD VDD sky130_fd_sc_hd__fill_8
* cell instance sky130_fd_sc_hd__fill_8_352 r0 *1 0,0
Xsky130_fd_sc_hd__fill_8_352 VSS VDD VDD sky130_fd_sc_hd__fill_8
* cell instance sky130_fd_sc_hd__fill_8_353 r0 *1 0,0
Xsky130_fd_sc_hd__fill_8_353 VSS VDD VDD sky130_fd_sc_hd__fill_8
* cell instance sky130_fd_sc_hd__fill_8_354 r0 *1 0,0
Xsky130_fd_sc_hd__fill_8_354 VSS VDD VDD sky130_fd_sc_hd__fill_8
* cell instance sky130_fd_sc_hd__fill_8_355 r0 *1 0,0
Xsky130_fd_sc_hd__fill_8_355 VSS VDD VDD sky130_fd_sc_hd__fill_8
* cell instance sky130_fd_sc_hd__fill_8_356 r0 *1 0,0
Xsky130_fd_sc_hd__fill_8_356 VSS VDD VDD sky130_fd_sc_hd__fill_8
* cell instance sky130_fd_sc_hd__fill_8_357 r0 *1 0,0
Xsky130_fd_sc_hd__fill_8_357 VSS VDD VDD sky130_fd_sc_hd__fill_8
* cell instance sky130_fd_sc_hd__fill_8_358 r0 *1 0,0
Xsky130_fd_sc_hd__fill_8_358 VSS VDD VDD sky130_fd_sc_hd__fill_8
* cell instance sky130_fd_sc_hd__fill_8_359 r0 *1 0,0
Xsky130_fd_sc_hd__fill_8_359 VSS VDD VDD sky130_fd_sc_hd__fill_8
* cell instance sky130_fd_sc_hd__fill_8_360 r0 *1 0,0
Xsky130_fd_sc_hd__fill_8_360 VSS VDD VDD sky130_fd_sc_hd__fill_8
* cell instance sky130_fd_sc_hd__fill_8_361 r0 *1 0,0
Xsky130_fd_sc_hd__fill_8_361 VSS VDD VDD sky130_fd_sc_hd__fill_8
* cell instance sky130_fd_sc_hd__fill_8_362 r0 *1 0,0
Xsky130_fd_sc_hd__fill_8_362 VSS VDD VDD sky130_fd_sc_hd__fill_8
* cell instance sky130_fd_sc_hd__fill_8_363 r0 *1 0,0
Xsky130_fd_sc_hd__fill_8_363 VSS VDD VDD sky130_fd_sc_hd__fill_8
* cell instance sky130_fd_sc_hd__fill_8_364 r0 *1 0,0
Xsky130_fd_sc_hd__fill_8_364 VSS VDD VDD sky130_fd_sc_hd__fill_8
* cell instance sky130_fd_sc_hd__fill_8_365 r0 *1 0,0
Xsky130_fd_sc_hd__fill_8_365 VSS VDD VDD sky130_fd_sc_hd__fill_8
* cell instance sky130_fd_sc_hd__fill_8_366 r0 *1 0,0
Xsky130_fd_sc_hd__fill_8_366 VSS VDD VDD sky130_fd_sc_hd__fill_8
* cell instance sky130_fd_sc_hd__fill_8_367 r0 *1 0,0
Xsky130_fd_sc_hd__fill_8_367 VSS VDD VDD sky130_fd_sc_hd__fill_8
* cell instance sky130_fd_sc_hd__fill_8_368 r0 *1 0,0
Xsky130_fd_sc_hd__fill_8_368 VSS VDD VDD sky130_fd_sc_hd__fill_8
* cell instance sky130_fd_sc_hd__fill_8_369 r0 *1 0,0
Xsky130_fd_sc_hd__fill_8_369 VSS VDD VDD sky130_fd_sc_hd__fill_8
* cell instance sky130_fd_sc_hd__fill_8_370 r0 *1 0,0
Xsky130_fd_sc_hd__fill_8_370 VSS VDD VDD sky130_fd_sc_hd__fill_8
* cell instance sky130_fd_sc_hd__fill_8_371 r0 *1 0,0
Xsky130_fd_sc_hd__fill_8_371 VSS VDD VDD sky130_fd_sc_hd__fill_8
* cell instance sky130_fd_sc_hd__fill_8_372 r0 *1 0,0
Xsky130_fd_sc_hd__fill_8_372 VSS VDD VDD sky130_fd_sc_hd__fill_8
* cell instance sky130_fd_sc_hd__fill_8_373 r0 *1 0,0
Xsky130_fd_sc_hd__fill_8_373 VSS VDD VDD sky130_fd_sc_hd__fill_8
* cell instance sky130_fd_sc_hd__fill_8_374 r0 *1 0,0
Xsky130_fd_sc_hd__fill_8_374 VSS VDD VDD sky130_fd_sc_hd__fill_8
* cell instance sky130_fd_sc_hd__fill_8_375 r0 *1 0,0
Xsky130_fd_sc_hd__fill_8_375 VSS VDD VDD sky130_fd_sc_hd__fill_8
* cell instance sky130_fd_sc_hd__fill_8_376 r0 *1 0,0
Xsky130_fd_sc_hd__fill_8_376 VSS VDD VDD sky130_fd_sc_hd__fill_8
* cell instance sky130_fd_sc_hd__fill_8_377 r0 *1 0,0
Xsky130_fd_sc_hd__fill_8_377 VSS VDD VDD sky130_fd_sc_hd__fill_8
* cell instance sky130_fd_sc_hd__fill_8_378 r0 *1 0,0
Xsky130_fd_sc_hd__fill_8_378 VSS VDD VDD sky130_fd_sc_hd__fill_8
* cell instance sky130_fd_sc_hd__fill_8_379 r0 *1 0,0
Xsky130_fd_sc_hd__fill_8_379 VSS VDD VDD sky130_fd_sc_hd__fill_8
* cell instance sky130_fd_sc_hd__fill_8_380 r0 *1 0,0
Xsky130_fd_sc_hd__fill_8_380 VSS VDD VDD sky130_fd_sc_hd__fill_8
* cell instance sky130_fd_sc_hd__fill_8_381 r0 *1 0,0
Xsky130_fd_sc_hd__fill_8_381 VSS VDD VDD sky130_fd_sc_hd__fill_8
* cell instance sky130_fd_sc_hd__fill_8_382 r0 *1 0,0
Xsky130_fd_sc_hd__fill_8_382 VSS VDD VDD sky130_fd_sc_hd__fill_8
* cell instance sky130_fd_sc_hd__fill_8_383 r0 *1 0,0
Xsky130_fd_sc_hd__fill_8_383 VSS VDD VDD sky130_fd_sc_hd__fill_8
* cell instance sky130_fd_sc_hd__fill_8_384 r0 *1 0,0
Xsky130_fd_sc_hd__fill_8_384 VSS VDD VDD sky130_fd_sc_hd__fill_8
* cell instance sky130_fd_sc_hd__fill_8_385 r0 *1 0,0
Xsky130_fd_sc_hd__fill_8_385 VSS VDD VDD sky130_fd_sc_hd__fill_8
* cell instance sky130_fd_sc_hd__fill_8_386 r0 *1 0,0
Xsky130_fd_sc_hd__fill_8_386 VSS VDD VDD sky130_fd_sc_hd__fill_8
* cell instance sky130_fd_sc_hd__fill_8_387 r0 *1 0,0
Xsky130_fd_sc_hd__fill_8_387 VSS VDD VDD sky130_fd_sc_hd__fill_8
* cell instance sky130_fd_sc_hd__fill_8_388 r0 *1 0,0
Xsky130_fd_sc_hd__fill_8_388 VSS VDD VDD sky130_fd_sc_hd__fill_8
* cell instance sky130_fd_sc_hd__fill_8_389 r0 *1 0,0
Xsky130_fd_sc_hd__fill_8_389 VSS VDD VDD sky130_fd_sc_hd__fill_8
* cell instance sky130_fd_sc_hd__fill_8_390 r0 *1 0,0
Xsky130_fd_sc_hd__fill_8_390 VSS VDD VDD sky130_fd_sc_hd__fill_8
* cell instance sky130_fd_sc_hd__fill_8_391 r0 *1 0,0
Xsky130_fd_sc_hd__fill_8_391 VSS VDD VDD sky130_fd_sc_hd__fill_8
* cell instance sky130_fd_sc_hd__fill_8_392 r0 *1 0,0
Xsky130_fd_sc_hd__fill_8_392 VSS VDD VDD sky130_fd_sc_hd__fill_8
* cell instance sky130_fd_sc_hd__fill_8_393 r0 *1 0,0
Xsky130_fd_sc_hd__fill_8_393 VSS VDD VDD sky130_fd_sc_hd__fill_8
* cell instance sky130_fd_sc_hd__fill_8_394 r0 *1 0,0
Xsky130_fd_sc_hd__fill_8_394 VSS VDD VDD sky130_fd_sc_hd__fill_8
* cell instance sky130_fd_sc_hd__fill_8_395 r0 *1 0,0
Xsky130_fd_sc_hd__fill_8_395 VSS VDD VDD sky130_fd_sc_hd__fill_8
* cell instance sky130_fd_sc_hd__fill_8_396 r0 *1 0,0
Xsky130_fd_sc_hd__fill_8_396 VSS VDD VDD sky130_fd_sc_hd__fill_8
* cell instance sky130_fd_sc_hd__fill_8_397 r0 *1 0,0
Xsky130_fd_sc_hd__fill_8_397 VSS VDD VDD sky130_fd_sc_hd__fill_8
* cell instance sky130_fd_sc_hd__fill_8_398 r0 *1 0,0
Xsky130_fd_sc_hd__fill_8_398 VSS VDD VDD sky130_fd_sc_hd__fill_8
* cell instance sky130_fd_sc_hd__fill_8_399 r0 *1 0,0
Xsky130_fd_sc_hd__fill_8_399 VSS VDD VDD sky130_fd_sc_hd__fill_8
* cell instance sky130_fd_sc_hd__fill_8_400 r0 *1 0,0
Xsky130_fd_sc_hd__fill_8_400 VSS VDD VDD sky130_fd_sc_hd__fill_8
* cell instance sky130_fd_sc_hd__fill_8_401 r0 *1 0,0
Xsky130_fd_sc_hd__fill_8_401 VSS VDD VDD sky130_fd_sc_hd__fill_8
* cell instance sky130_fd_sc_hd__fill_8_402 r0 *1 0,0
Xsky130_fd_sc_hd__fill_8_402 VSS VDD VDD sky130_fd_sc_hd__fill_8
* cell instance sky130_fd_sc_hd__fill_8_403 r0 *1 0,0
Xsky130_fd_sc_hd__fill_8_403 VSS VDD VDD sky130_fd_sc_hd__fill_8
* cell instance sky130_fd_sc_hd__fill_8_404 r0 *1 0,0
Xsky130_fd_sc_hd__fill_8_404 VSS VDD VDD sky130_fd_sc_hd__fill_8
* cell instance sky130_fd_sc_hd__fill_8_405 r0 *1 0,0
Xsky130_fd_sc_hd__fill_8_405 VSS VDD VDD sky130_fd_sc_hd__fill_8
* cell instance sky130_fd_sc_hd__fill_8_406 r0 *1 0,0
Xsky130_fd_sc_hd__fill_8_406 VSS VDD VDD sky130_fd_sc_hd__fill_8
* cell instance sky130_fd_sc_hd__fill_8_407 r0 *1 0,0
Xsky130_fd_sc_hd__fill_8_407 VSS VDD VDD sky130_fd_sc_hd__fill_8
* cell instance sky130_fd_sc_hd__fill_8_408 r0 *1 0,0
Xsky130_fd_sc_hd__fill_8_408 VSS VDD VDD sky130_fd_sc_hd__fill_8
* cell instance sky130_fd_sc_hd__fill_8_409 r0 *1 0,0
Xsky130_fd_sc_hd__fill_8_409 VSS VDD VDD sky130_fd_sc_hd__fill_8
* cell instance sky130_fd_sc_hd__fill_8_410 r0 *1 0,0
Xsky130_fd_sc_hd__fill_8_410 VSS VDD VDD sky130_fd_sc_hd__fill_8
* cell instance sky130_fd_sc_hd__fill_8_411 r0 *1 0,0
Xsky130_fd_sc_hd__fill_8_411 VSS VDD VDD sky130_fd_sc_hd__fill_8
* cell instance sky130_fd_sc_hd__fill_8_412 r0 *1 0,0
Xsky130_fd_sc_hd__fill_8_412 VSS VDD VDD sky130_fd_sc_hd__fill_8
* cell instance sky130_fd_sc_hd__fill_8_413 r0 *1 0,0
Xsky130_fd_sc_hd__fill_8_413 VSS VDD VDD sky130_fd_sc_hd__fill_8
* cell instance sky130_fd_sc_hd__fill_8_414 r0 *1 0,0
Xsky130_fd_sc_hd__fill_8_414 VSS VDD VDD sky130_fd_sc_hd__fill_8
* cell instance sky130_fd_sc_hd__fill_8_415 r0 *1 0,0
Xsky130_fd_sc_hd__fill_8_415 VSS VDD VDD sky130_fd_sc_hd__fill_8
* cell instance sky130_fd_sc_hd__fill_8_416 r0 *1 0,0
Xsky130_fd_sc_hd__fill_8_416 VSS VDD VDD sky130_fd_sc_hd__fill_8
* cell instance sky130_fd_sc_hd__fill_8_417 r0 *1 0,0
Xsky130_fd_sc_hd__fill_8_417 VSS VDD VDD sky130_fd_sc_hd__fill_8
* cell instance sky130_fd_sc_hd__fill_8_418 r0 *1 0,0
Xsky130_fd_sc_hd__fill_8_418 VSS VDD VDD sky130_fd_sc_hd__fill_8
* cell instance sky130_fd_sc_hd__fill_8_419 r0 *1 0,0
Xsky130_fd_sc_hd__fill_8_419 VSS VDD VDD sky130_fd_sc_hd__fill_8
* cell instance sky130_fd_sc_hd__fill_8_420 r0 *1 0,0
Xsky130_fd_sc_hd__fill_8_420 VSS VDD VDD sky130_fd_sc_hd__fill_8
* cell instance sky130_fd_sc_hd__fill_8_421 r0 *1 0,0
Xsky130_fd_sc_hd__fill_8_421 VSS VDD VDD sky130_fd_sc_hd__fill_8
* cell instance sky130_fd_sc_hd__fill_8_422 r0 *1 0,0
Xsky130_fd_sc_hd__fill_8_422 VSS VDD VDD sky130_fd_sc_hd__fill_8
* cell instance sky130_fd_sc_hd__fill_8_423 r0 *1 0,0
Xsky130_fd_sc_hd__fill_8_423 VSS VDD VDD sky130_fd_sc_hd__fill_8
* cell instance sky130_fd_sc_hd__fill_8_424 r0 *1 0,0
Xsky130_fd_sc_hd__fill_8_424 VSS VDD VDD sky130_fd_sc_hd__fill_8
* cell instance sky130_fd_sc_hd__fill_8_425 r0 *1 0,0
Xsky130_fd_sc_hd__fill_8_425 VSS VDD VDD sky130_fd_sc_hd__fill_8
* cell instance sky130_fd_sc_hd__fill_8_426 r0 *1 0,0
Xsky130_fd_sc_hd__fill_8_426 VSS VDD VDD sky130_fd_sc_hd__fill_8
* cell instance sky130_fd_sc_hd__fill_8_427 r0 *1 0,0
Xsky130_fd_sc_hd__fill_8_427 VSS VDD VDD sky130_fd_sc_hd__fill_8
* cell instance sky130_fd_sc_hd__fill_8_428 r0 *1 0,0
Xsky130_fd_sc_hd__fill_8_428 VSS VDD VDD sky130_fd_sc_hd__fill_8
* cell instance sky130_fd_sc_hd__fill_8_429 r0 *1 0,0
Xsky130_fd_sc_hd__fill_8_429 VSS VDD VDD sky130_fd_sc_hd__fill_8
* cell instance sky130_fd_sc_hd__fill_8_430 r0 *1 0,0
Xsky130_fd_sc_hd__fill_8_430 VSS VDD VDD sky130_fd_sc_hd__fill_8
* cell instance sky130_fd_sc_hd__fill_8_431 r0 *1 0,0
Xsky130_fd_sc_hd__fill_8_431 VSS VDD VDD sky130_fd_sc_hd__fill_8
* cell instance sky130_fd_sc_hd__fill_8_432 r0 *1 0,0
Xsky130_fd_sc_hd__fill_8_432 VSS VDD VDD sky130_fd_sc_hd__fill_8
* cell instance sky130_fd_sc_hd__fill_8_433 r0 *1 0,0
Xsky130_fd_sc_hd__fill_8_433 VSS VDD VDD sky130_fd_sc_hd__fill_8
* cell instance sky130_fd_sc_hd__fill_8_434 r0 *1 0,0
Xsky130_fd_sc_hd__fill_8_434 VSS VDD VDD sky130_fd_sc_hd__fill_8
* cell instance sky130_fd_sc_hd__fill_8_435 r0 *1 0,0
Xsky130_fd_sc_hd__fill_8_435 VSS VDD VDD sky130_fd_sc_hd__fill_8
* cell instance sky130_fd_sc_hd__fill_8_436 r0 *1 0,0
Xsky130_fd_sc_hd__fill_8_436 VSS VDD VDD sky130_fd_sc_hd__fill_8
* cell instance sky130_fd_sc_hd__fill_8_437 r0 *1 0,0
Xsky130_fd_sc_hd__fill_8_437 VSS VDD VDD sky130_fd_sc_hd__fill_8
* cell instance sky130_fd_sc_hd__fill_8_438 r0 *1 0,0
Xsky130_fd_sc_hd__fill_8_438 VSS VDD VDD sky130_fd_sc_hd__fill_8
* cell instance sky130_fd_sc_hd__fill_8_439 r0 *1 0,0
Xsky130_fd_sc_hd__fill_8_439 VSS VDD VDD sky130_fd_sc_hd__fill_8
* cell instance sky130_fd_sc_hd__fill_8_440 r0 *1 0,0
Xsky130_fd_sc_hd__fill_8_440 VSS VDD VDD sky130_fd_sc_hd__fill_8
* cell instance sky130_fd_sc_hd__fill_8_441 r0 *1 0,0
Xsky130_fd_sc_hd__fill_8_441 VSS VDD VDD sky130_fd_sc_hd__fill_8
* cell instance sky130_fd_sc_hd__fill_8_442 r0 *1 0,0
Xsky130_fd_sc_hd__fill_8_442 VSS VDD VDD sky130_fd_sc_hd__fill_8
* cell instance sky130_fd_sc_hd__fill_8_443 r0 *1 0,0
Xsky130_fd_sc_hd__fill_8_443 VSS VDD VDD sky130_fd_sc_hd__fill_8
* cell instance sky130_fd_sc_hd__fill_8_444 r0 *1 0,0
Xsky130_fd_sc_hd__fill_8_444 VSS VDD VDD sky130_fd_sc_hd__fill_8
* cell instance sky130_fd_sc_hd__fill_8_445 r0 *1 0,0
Xsky130_fd_sc_hd__fill_8_445 VSS VDD VDD sky130_fd_sc_hd__fill_8
* cell instance sky130_fd_sc_hd__fill_8_446 r0 *1 0,0
Xsky130_fd_sc_hd__fill_8_446 VSS VDD VDD sky130_fd_sc_hd__fill_8
* cell instance sky130_fd_sc_hd__fill_8_447 r0 *1 0,0
Xsky130_fd_sc_hd__fill_8_447 VSS VDD VDD sky130_fd_sc_hd__fill_8
* cell instance sky130_fd_sc_hd__fill_8_448 r0 *1 0,0
Xsky130_fd_sc_hd__fill_8_448 VSS VDD VDD sky130_fd_sc_hd__fill_8
* cell instance sky130_fd_sc_hd__fill_8_449 r0 *1 0,0
Xsky130_fd_sc_hd__fill_8_449 VSS VDD VDD sky130_fd_sc_hd__fill_8
* cell instance sky130_fd_sc_hd__fill_8_450 r0 *1 0,0
Xsky130_fd_sc_hd__fill_8_450 VSS VDD VDD sky130_fd_sc_hd__fill_8
* cell instance sky130_fd_sc_hd__fill_8_451 r0 *1 0,0
Xsky130_fd_sc_hd__fill_8_451 VSS VDD VDD sky130_fd_sc_hd__fill_8
* cell instance sky130_fd_sc_hd__fill_8_452 r0 *1 0,0
Xsky130_fd_sc_hd__fill_8_452 VSS VDD VDD sky130_fd_sc_hd__fill_8
* cell instance sky130_fd_sc_hd__fill_8_453 r0 *1 0,0
Xsky130_fd_sc_hd__fill_8_453 VSS VDD VDD sky130_fd_sc_hd__fill_8
* cell instance sky130_fd_sc_hd__fill_8_454 r0 *1 0,0
Xsky130_fd_sc_hd__fill_8_454 VSS VDD VDD sky130_fd_sc_hd__fill_8
* cell instance sky130_fd_sc_hd__fill_8_455 r0 *1 0,0
Xsky130_fd_sc_hd__fill_8_455 VSS VDD VDD sky130_fd_sc_hd__fill_8
* cell instance sky130_fd_sc_hd__fill_8_456 r0 *1 0,0
Xsky130_fd_sc_hd__fill_8_456 VSS VDD VDD sky130_fd_sc_hd__fill_8
* cell instance sky130_fd_sc_hd__fill_8_457 r0 *1 0,0
Xsky130_fd_sc_hd__fill_8_457 VSS VDD VDD sky130_fd_sc_hd__fill_8
* cell instance sky130_fd_sc_hd__fill_8_458 r0 *1 0,0
Xsky130_fd_sc_hd__fill_8_458 VSS VDD VDD sky130_fd_sc_hd__fill_8
* cell instance sky130_fd_sc_hd__fill_8_459 r0 *1 0,0
Xsky130_fd_sc_hd__fill_8_459 VSS VDD VDD sky130_fd_sc_hd__fill_8
* cell instance sky130_fd_sc_hd__fill_8_460 r0 *1 0,0
Xsky130_fd_sc_hd__fill_8_460 VSS VDD VDD sky130_fd_sc_hd__fill_8
* cell instance sky130_fd_sc_hd__fill_8_461 r0 *1 0,0
Xsky130_fd_sc_hd__fill_8_461 VSS VDD VDD sky130_fd_sc_hd__fill_8
* cell instance sky130_fd_sc_hd__fill_8_462 r0 *1 0,0
Xsky130_fd_sc_hd__fill_8_462 VSS VDD VDD sky130_fd_sc_hd__fill_8
* cell instance sky130_fd_sc_hd__fill_8_463 r0 *1 0,0
Xsky130_fd_sc_hd__fill_8_463 VSS VDD VDD sky130_fd_sc_hd__fill_8
* cell instance sky130_fd_sc_hd__fill_8_464 r0 *1 0,0
Xsky130_fd_sc_hd__fill_8_464 VSS VDD VDD sky130_fd_sc_hd__fill_8
* cell instance sky130_fd_sc_hd__fill_8_465 r0 *1 0,0
Xsky130_fd_sc_hd__fill_8_465 VSS VDD VDD sky130_fd_sc_hd__fill_8
* cell instance sky130_fd_sc_hd__fill_8_466 r0 *1 0,0
Xsky130_fd_sc_hd__fill_8_466 VSS VDD VDD sky130_fd_sc_hd__fill_8
* cell instance sky130_fd_sc_hd__fill_8_467 r0 *1 0,0
Xsky130_fd_sc_hd__fill_8_467 VSS VDD VDD sky130_fd_sc_hd__fill_8
* cell instance sky130_fd_sc_hd__fill_8_468 r0 *1 0,0
Xsky130_fd_sc_hd__fill_8_468 VSS VDD VDD sky130_fd_sc_hd__fill_8
* cell instance sky130_fd_sc_hd__fill_8_469 r0 *1 0,0
Xsky130_fd_sc_hd__fill_8_469 VSS VDD VDD sky130_fd_sc_hd__fill_8
* cell instance sky130_fd_sc_hd__fill_8_470 r0 *1 0,0
Xsky130_fd_sc_hd__fill_8_470 VSS VDD VDD sky130_fd_sc_hd__fill_8
* cell instance sky130_fd_sc_hd__fill_8_471 r0 *1 0,0
Xsky130_fd_sc_hd__fill_8_471 VSS VDD VDD sky130_fd_sc_hd__fill_8
* cell instance sky130_fd_sc_hd__fill_8_472 r0 *1 0,0
Xsky130_fd_sc_hd__fill_8_472 VSS VDD VDD sky130_fd_sc_hd__fill_8
* cell instance sky130_fd_sc_hd__fill_8_473 r0 *1 0,0
Xsky130_fd_sc_hd__fill_8_473 VSS VDD VDD sky130_fd_sc_hd__fill_8
* cell instance sky130_fd_sc_hd__fill_8_474 r0 *1 0,0
Xsky130_fd_sc_hd__fill_8_474 VSS VDD VDD sky130_fd_sc_hd__fill_8
* cell instance sky130_fd_sc_hd__fill_8_475 r0 *1 0,0
Xsky130_fd_sc_hd__fill_8_475 VSS VDD VDD sky130_fd_sc_hd__fill_8
* cell instance sky130_fd_sc_hd__fill_8_476 r0 *1 0,0
Xsky130_fd_sc_hd__fill_8_476 VSS VDD VDD sky130_fd_sc_hd__fill_8
* cell instance sky130_fd_sc_hd__fill_8_477 r0 *1 0,0
Xsky130_fd_sc_hd__fill_8_477 VSS VDD VDD sky130_fd_sc_hd__fill_8
* cell instance sky130_fd_sc_hd__fill_8_478 r0 *1 0,0
Xsky130_fd_sc_hd__fill_8_478 VSS VDD VDD sky130_fd_sc_hd__fill_8
* cell instance sky130_fd_sc_hd__fill_8_479 r0 *1 0,0
Xsky130_fd_sc_hd__fill_8_479 VSS VDD VDD sky130_fd_sc_hd__fill_8
* cell instance sky130_fd_sc_hd__fill_8_480 r0 *1 0,0
Xsky130_fd_sc_hd__fill_8_480 VSS VDD VDD sky130_fd_sc_hd__fill_8
* cell instance sky130_fd_sc_hd__fill_8_481 r0 *1 0,0
Xsky130_fd_sc_hd__fill_8_481 VSS VDD VDD sky130_fd_sc_hd__fill_8
* cell instance sky130_fd_sc_hd__fill_8_482 r0 *1 0,0
Xsky130_fd_sc_hd__fill_8_482 VSS VDD VDD sky130_fd_sc_hd__fill_8
* cell instance sky130_fd_sc_hd__fill_8_483 r0 *1 0,0
Xsky130_fd_sc_hd__fill_8_483 VSS VDD VDD sky130_fd_sc_hd__fill_8
* cell instance sky130_fd_sc_hd__fill_8_484 r0 *1 0,0
Xsky130_fd_sc_hd__fill_8_484 VSS VDD VDD sky130_fd_sc_hd__fill_8
* cell instance sky130_fd_sc_hd__fill_8_485 r0 *1 0,0
Xsky130_fd_sc_hd__fill_8_485 VSS VDD VDD sky130_fd_sc_hd__fill_8
* cell instance sky130_fd_sc_hd__fill_8_486 r0 *1 0,0
Xsky130_fd_sc_hd__fill_8_486 VSS VDD VDD sky130_fd_sc_hd__fill_8
* cell instance sky130_fd_sc_hd__fill_8_487 r0 *1 0,0
Xsky130_fd_sc_hd__fill_8_487 VSS VDD VDD sky130_fd_sc_hd__fill_8
* cell instance sky130_fd_sc_hd__fill_8_488 r0 *1 0,0
Xsky130_fd_sc_hd__fill_8_488 VSS VDD VDD sky130_fd_sc_hd__fill_8
* cell instance sky130_fd_sc_hd__fill_8_489 r0 *1 0,0
Xsky130_fd_sc_hd__fill_8_489 VSS VDD VDD sky130_fd_sc_hd__fill_8
* cell instance sky130_fd_sc_hd__fill_8_490 r0 *1 0,0
Xsky130_fd_sc_hd__fill_8_490 VSS VDD VDD sky130_fd_sc_hd__fill_8
* cell instance sky130_fd_sc_hd__fill_8_491 r0 *1 0,0
Xsky130_fd_sc_hd__fill_8_491 VSS VDD VDD sky130_fd_sc_hd__fill_8
* cell instance sky130_fd_sc_hd__fill_8_492 r0 *1 0,0
Xsky130_fd_sc_hd__fill_8_492 VSS VDD VDD sky130_fd_sc_hd__fill_8
* cell instance sky130_fd_sc_hd__fill_8_493 r0 *1 0,0
Xsky130_fd_sc_hd__fill_8_493 VSS VDD VDD sky130_fd_sc_hd__fill_8
* cell instance sky130_fd_sc_hd__fill_8_494 r0 *1 0,0
Xsky130_fd_sc_hd__fill_8_494 VSS VDD VDD sky130_fd_sc_hd__fill_8
* cell instance sky130_fd_sc_hd__fill_8_495 r0 *1 0,0
Xsky130_fd_sc_hd__fill_8_495 VSS VDD VDD sky130_fd_sc_hd__fill_8
* cell instance sky130_fd_sc_hd__fill_8_496 r0 *1 0,0
Xsky130_fd_sc_hd__fill_8_496 VSS VDD VDD sky130_fd_sc_hd__fill_8
* cell instance sky130_fd_sc_hd__fill_8_497 r0 *1 0,0
Xsky130_fd_sc_hd__fill_8_497 VSS VDD VDD sky130_fd_sc_hd__fill_8
* cell instance sky130_fd_sc_hd__fill_8_498 r0 *1 0,0
Xsky130_fd_sc_hd__fill_8_498 VSS VDD VDD sky130_fd_sc_hd__fill_8
* cell instance sky130_fd_sc_hd__fill_8_499 r0 *1 0,0
Xsky130_fd_sc_hd__fill_8_499 VSS VDD VDD sky130_fd_sc_hd__fill_8
* cell instance sky130_fd_sc_hd__fill_8_500 r0 *1 0,0
Xsky130_fd_sc_hd__fill_8_500 VSS VDD VDD sky130_fd_sc_hd__fill_8
* cell instance sky130_fd_sc_hd__fill_8_501 r0 *1 0,0
Xsky130_fd_sc_hd__fill_8_501 VSS VDD VDD sky130_fd_sc_hd__fill_8
* cell instance sky130_fd_sc_hd__fill_8_502 r0 *1 0,0
Xsky130_fd_sc_hd__fill_8_502 VSS VDD VDD sky130_fd_sc_hd__fill_8
* cell instance sky130_fd_sc_hd__fill_8_503 r0 *1 0,0
Xsky130_fd_sc_hd__fill_8_503 VSS VDD VDD sky130_fd_sc_hd__fill_8
* cell instance sky130_fd_sc_hd__fill_8_504 r0 *1 0,0
Xsky130_fd_sc_hd__fill_8_504 VSS VDD VDD sky130_fd_sc_hd__fill_8
* cell instance sky130_fd_sc_hd__fill_8_505 r0 *1 0,0
Xsky130_fd_sc_hd__fill_8_505 VSS VDD VDD sky130_fd_sc_hd__fill_8
* cell instance sky130_fd_sc_hd__fill_8_506 r0 *1 0,0
Xsky130_fd_sc_hd__fill_8_506 VSS VDD VDD sky130_fd_sc_hd__fill_8
* cell instance sky130_fd_sc_hd__fill_8_507 r0 *1 0,0
Xsky130_fd_sc_hd__fill_8_507 VSS VDD VDD sky130_fd_sc_hd__fill_8
* cell instance sky130_fd_sc_hd__fill_8_508 r0 *1 0,0
Xsky130_fd_sc_hd__fill_8_508 VSS VDD VDD sky130_fd_sc_hd__fill_8
* cell instance sky130_fd_sc_hd__fill_8_509 r0 *1 0,0
Xsky130_fd_sc_hd__fill_8_509 VSS VDD VDD sky130_fd_sc_hd__fill_8
* cell instance sky130_fd_sc_hd__fill_8_510 r0 *1 0,0
Xsky130_fd_sc_hd__fill_8_510 VSS VDD VDD sky130_fd_sc_hd__fill_8
* cell instance sky130_fd_sc_hd__fill_8_511 r0 *1 0,0
Xsky130_fd_sc_hd__fill_8_511 VSS VDD VDD sky130_fd_sc_hd__fill_8
* cell instance sky130_fd_sc_hd__fill_8_512 r0 *1 0,0
Xsky130_fd_sc_hd__fill_8_512 VSS VDD VDD sky130_fd_sc_hd__fill_8
* cell instance sky130_fd_sc_hd__fill_8_513 r0 *1 0,0
Xsky130_fd_sc_hd__fill_8_513 VSS VDD VDD sky130_fd_sc_hd__fill_8
* cell instance sky130_fd_sc_hd__fill_8_514 r0 *1 0,0
Xsky130_fd_sc_hd__fill_8_514 VSS VDD VDD sky130_fd_sc_hd__fill_8
* cell instance sky130_fd_sc_hd__fill_8_515 r0 *1 0,0
Xsky130_fd_sc_hd__fill_8_515 VSS VDD VDD sky130_fd_sc_hd__fill_8
* cell instance sky130_fd_sc_hd__fill_8_516 r0 *1 0,0
Xsky130_fd_sc_hd__fill_8_516 VSS VDD VDD sky130_fd_sc_hd__fill_8
* cell instance sky130_fd_sc_hd__fill_8_517 r0 *1 0,0
Xsky130_fd_sc_hd__fill_8_517 VSS VDD VDD sky130_fd_sc_hd__fill_8
* cell instance sky130_fd_sc_hd__fill_8_518 r0 *1 0,0
Xsky130_fd_sc_hd__fill_8_518 VSS VDD VDD sky130_fd_sc_hd__fill_8
* cell instance sky130_fd_sc_hd__fill_8_519 r0 *1 0,0
Xsky130_fd_sc_hd__fill_8_519 VSS VDD VDD sky130_fd_sc_hd__fill_8
* cell instance sky130_fd_sc_hd__fill_8_520 r0 *1 0,0
Xsky130_fd_sc_hd__fill_8_520 VSS VDD VDD sky130_fd_sc_hd__fill_8
* cell instance sky130_fd_sc_hd__fill_8_521 r0 *1 0,0
Xsky130_fd_sc_hd__fill_8_521 VSS VDD VDD sky130_fd_sc_hd__fill_8
* cell instance sky130_fd_sc_hd__fill_8_522 r0 *1 0,0
Xsky130_fd_sc_hd__fill_8_522 VSS VDD VDD sky130_fd_sc_hd__fill_8
* cell instance sky130_fd_sc_hd__fill_8_523 r0 *1 0,0
Xsky130_fd_sc_hd__fill_8_523 VSS VDD VDD sky130_fd_sc_hd__fill_8
* cell instance sky130_fd_sc_hd__fill_8_524 r0 *1 0,0
Xsky130_fd_sc_hd__fill_8_524 VSS VDD VDD sky130_fd_sc_hd__fill_8
* cell instance sky130_fd_sc_hd__fill_8_525 r0 *1 0,0
Xsky130_fd_sc_hd__fill_8_525 VSS VDD VDD sky130_fd_sc_hd__fill_8
* cell instance sky130_fd_sc_hd__fill_8_526 r0 *1 0,0
Xsky130_fd_sc_hd__fill_8_526 VSS VDD VDD sky130_fd_sc_hd__fill_8
* cell instance sky130_fd_sc_hd__fill_8_527 r0 *1 0,0
Xsky130_fd_sc_hd__fill_8_527 VSS VDD VDD sky130_fd_sc_hd__fill_8
* cell instance sky130_fd_sc_hd__fill_8_528 r0 *1 0,0
Xsky130_fd_sc_hd__fill_8_528 VSS VDD VDD sky130_fd_sc_hd__fill_8
* cell instance sky130_fd_sc_hd__fill_8_529 r0 *1 0,0
Xsky130_fd_sc_hd__fill_8_529 VSS VDD VDD sky130_fd_sc_hd__fill_8
* cell instance sky130_fd_sc_hd__fill_8_530 r0 *1 0,0
Xsky130_fd_sc_hd__fill_8_530 VSS VDD VDD sky130_fd_sc_hd__fill_8
* cell instance sky130_fd_sc_hd__fill_8_531 r0 *1 0,0
Xsky130_fd_sc_hd__fill_8_531 VSS VDD VDD sky130_fd_sc_hd__fill_8
* cell instance sky130_fd_sc_hd__fill_8_532 r0 *1 0,0
Xsky130_fd_sc_hd__fill_8_532 VSS VDD VDD sky130_fd_sc_hd__fill_8
* cell instance sky130_fd_sc_hd__fill_8_533 r0 *1 0,0
Xsky130_fd_sc_hd__fill_8_533 VSS VDD VDD sky130_fd_sc_hd__fill_8
* cell instance sky130_fd_sc_hd__fill_8_534 r0 *1 0,0
Xsky130_fd_sc_hd__fill_8_534 VSS VDD VDD sky130_fd_sc_hd__fill_8
* cell instance sky130_fd_sc_hd__fill_8_535 r0 *1 0,0
Xsky130_fd_sc_hd__fill_8_535 VSS VDD VDD sky130_fd_sc_hd__fill_8
* cell instance sky130_fd_sc_hd__fill_8_536 r0 *1 0,0
Xsky130_fd_sc_hd__fill_8_536 VSS VDD VDD sky130_fd_sc_hd__fill_8
* cell instance sky130_fd_sc_hd__fill_8_537 r0 *1 0,0
Xsky130_fd_sc_hd__fill_8_537 VSS VDD VDD sky130_fd_sc_hd__fill_8
* cell instance sky130_fd_sc_hd__fill_8_538 r0 *1 0,0
Xsky130_fd_sc_hd__fill_8_538 VSS VDD VDD sky130_fd_sc_hd__fill_8
* cell instance sky130_fd_sc_hd__fill_8_539 r0 *1 0,0
Xsky130_fd_sc_hd__fill_8_539 VSS VDD VDD sky130_fd_sc_hd__fill_8
* cell instance sky130_fd_sc_hd__fill_8_540 r0 *1 0,0
Xsky130_fd_sc_hd__fill_8_540 VSS VDD VDD sky130_fd_sc_hd__fill_8
* cell instance sky130_fd_sc_hd__fill_8_541 r0 *1 0,0
Xsky130_fd_sc_hd__fill_8_541 VSS VDD VDD sky130_fd_sc_hd__fill_8
* cell instance sky130_fd_sc_hd__fill_8_542 r0 *1 0,0
Xsky130_fd_sc_hd__fill_8_542 VSS VDD VDD sky130_fd_sc_hd__fill_8
* cell instance sky130_fd_sc_hd__fill_8_543 r0 *1 0,0
Xsky130_fd_sc_hd__fill_8_543 VSS VDD VDD sky130_fd_sc_hd__fill_8
* cell instance sky130_fd_sc_hd__fill_8_544 r0 *1 0,0
Xsky130_fd_sc_hd__fill_8_544 VSS VDD VDD sky130_fd_sc_hd__fill_8
* cell instance sky130_fd_sc_hd__fill_8_545 r0 *1 0,0
Xsky130_fd_sc_hd__fill_8_545 VSS VDD VDD sky130_fd_sc_hd__fill_8
* cell instance sky130_fd_sc_hd__fill_8_546 r0 *1 0,0
Xsky130_fd_sc_hd__fill_8_546 VSS VDD VDD sky130_fd_sc_hd__fill_8
* cell instance sky130_fd_sc_hd__fill_8_547 r0 *1 0,0
Xsky130_fd_sc_hd__fill_8_547 VSS VDD VDD sky130_fd_sc_hd__fill_8
* cell instance sky130_fd_sc_hd__fill_8_548 r0 *1 0,0
Xsky130_fd_sc_hd__fill_8_548 VSS VDD VDD sky130_fd_sc_hd__fill_8
* cell instance sky130_fd_sc_hd__fill_8_549 r0 *1 0,0
Xsky130_fd_sc_hd__fill_8_549 VSS VDD VDD sky130_fd_sc_hd__fill_8
* cell instance sky130_fd_sc_hd__fill_8_550 r0 *1 0,0
Xsky130_fd_sc_hd__fill_8_550 VSS VDD VDD sky130_fd_sc_hd__fill_8
* cell instance sky130_fd_sc_hd__fill_8_551 r0 *1 0,0
Xsky130_fd_sc_hd__fill_8_551 VSS VDD VDD sky130_fd_sc_hd__fill_8
* cell instance sky130_fd_sc_hd__fill_8_552 r0 *1 0,0
Xsky130_fd_sc_hd__fill_8_552 VSS VDD VDD sky130_fd_sc_hd__fill_8
* cell instance sky130_fd_sc_hd__fill_8_553 r0 *1 0,0
Xsky130_fd_sc_hd__fill_8_553 VSS VDD VDD sky130_fd_sc_hd__fill_8
* cell instance sky130_fd_sc_hd__fill_8_554 r0 *1 0,0
Xsky130_fd_sc_hd__fill_8_554 VSS VDD VDD sky130_fd_sc_hd__fill_8
* cell instance sky130_fd_sc_hd__fill_8_555 r0 *1 0,0
Xsky130_fd_sc_hd__fill_8_555 VSS VDD VDD sky130_fd_sc_hd__fill_8
* cell instance sky130_fd_sc_hd__fill_8_556 r0 *1 0,0
Xsky130_fd_sc_hd__fill_8_556 VSS VDD VDD sky130_fd_sc_hd__fill_8
* cell instance sky130_fd_sc_hd__fill_8_557 r0 *1 0,0
Xsky130_fd_sc_hd__fill_8_557 VSS VDD VDD sky130_fd_sc_hd__fill_8
* cell instance sky130_fd_sc_hd__fill_8_558 r0 *1 0,0
Xsky130_fd_sc_hd__fill_8_558 VSS VDD VDD sky130_fd_sc_hd__fill_8
* cell instance sky130_fd_sc_hd__fill_8_559 r0 *1 0,0
Xsky130_fd_sc_hd__fill_8_559 VSS VDD VDD sky130_fd_sc_hd__fill_8
* cell instance sky130_fd_sc_hd__fill_8_560 r0 *1 0,0
Xsky130_fd_sc_hd__fill_8_560 VSS VDD VDD sky130_fd_sc_hd__fill_8
* cell instance sky130_fd_sc_hd__fill_8_561 r0 *1 0,0
Xsky130_fd_sc_hd__fill_8_561 VSS VDD VDD sky130_fd_sc_hd__fill_8
* cell instance sky130_fd_sc_hd__fill_8_562 r0 *1 0,0
Xsky130_fd_sc_hd__fill_8_562 VSS VDD VDD sky130_fd_sc_hd__fill_8
* cell instance sky130_fd_sc_hd__fill_8_563 r0 *1 0,0
Xsky130_fd_sc_hd__fill_8_563 VSS VDD VDD sky130_fd_sc_hd__fill_8
* cell instance sky130_fd_sc_hd__fill_8_564 r0 *1 0,0
Xsky130_fd_sc_hd__fill_8_564 VSS VDD VDD sky130_fd_sc_hd__fill_8
* cell instance sky130_fd_sc_hd__fill_8_565 r0 *1 0,0
Xsky130_fd_sc_hd__fill_8_565 VSS VDD VDD sky130_fd_sc_hd__fill_8
* cell instance sky130_fd_sc_hd__fill_8_566 r0 *1 0,0
Xsky130_fd_sc_hd__fill_8_566 VSS VDD VDD sky130_fd_sc_hd__fill_8
* cell instance sky130_fd_sc_hd__fill_8_567 r0 *1 0,0
Xsky130_fd_sc_hd__fill_8_567 VSS VDD VDD sky130_fd_sc_hd__fill_8
* cell instance sky130_fd_sc_hd__fill_8_568 r0 *1 0,0
Xsky130_fd_sc_hd__fill_8_568 VSS VDD VDD sky130_fd_sc_hd__fill_8
* cell instance sky130_fd_sc_hd__fill_8_569 r0 *1 0,0
Xsky130_fd_sc_hd__fill_8_569 VSS VDD VDD sky130_fd_sc_hd__fill_8
* cell instance sky130_fd_sc_hd__fill_8_570 r0 *1 0,0
Xsky130_fd_sc_hd__fill_8_570 VSS VDD VDD sky130_fd_sc_hd__fill_8
* cell instance sky130_fd_sc_hd__fill_8_571 r0 *1 0,0
Xsky130_fd_sc_hd__fill_8_571 VSS VDD VDD sky130_fd_sc_hd__fill_8
* cell instance sky130_fd_sc_hd__fill_8_572 r0 *1 0,0
Xsky130_fd_sc_hd__fill_8_572 VSS VDD VDD sky130_fd_sc_hd__fill_8
* cell instance sky130_fd_sc_hd__fill_8_573 r0 *1 0,0
Xsky130_fd_sc_hd__fill_8_573 VSS VDD VDD sky130_fd_sc_hd__fill_8
* cell instance sky130_fd_sc_hd__fill_8_574 r0 *1 0,0
Xsky130_fd_sc_hd__fill_8_574 VSS VDD VDD sky130_fd_sc_hd__fill_8
* cell instance sky130_fd_sc_hd__fill_8_575 r0 *1 0,0
Xsky130_fd_sc_hd__fill_8_575 VSS VDD VDD sky130_fd_sc_hd__fill_8
* cell instance sky130_fd_sc_hd__fill_8_576 r0 *1 0,0
Xsky130_fd_sc_hd__fill_8_576 VSS VDD VDD sky130_fd_sc_hd__fill_8
* cell instance sky130_fd_sc_hd__fill_8_577 r0 *1 0,0
Xsky130_fd_sc_hd__fill_8_577 VSS VDD VDD sky130_fd_sc_hd__fill_8
* cell instance sky130_fd_sc_hd__fill_8_578 r0 *1 0,0
Xsky130_fd_sc_hd__fill_8_578 VSS VDD VDD sky130_fd_sc_hd__fill_8
* cell instance sky130_fd_sc_hd__fill_8_579 r0 *1 0,0
Xsky130_fd_sc_hd__fill_8_579 VSS VDD VDD sky130_fd_sc_hd__fill_8
* cell instance sky130_fd_sc_hd__fill_8_580 r0 *1 0,0
Xsky130_fd_sc_hd__fill_8_580 VSS VDD VDD sky130_fd_sc_hd__fill_8
* cell instance sky130_fd_sc_hd__fill_8_581 r0 *1 0,0
Xsky130_fd_sc_hd__fill_8_581 VSS VDD VDD sky130_fd_sc_hd__fill_8
* cell instance sky130_fd_sc_hd__fill_8_582 r0 *1 0,0
Xsky130_fd_sc_hd__fill_8_582 VSS VDD VDD sky130_fd_sc_hd__fill_8
* cell instance sky130_fd_sc_hd__fill_8_583 r0 *1 0,0
Xsky130_fd_sc_hd__fill_8_583 VSS VDD VDD sky130_fd_sc_hd__fill_8
* cell instance sky130_fd_sc_hd__fill_8_584 r0 *1 0,0
Xsky130_fd_sc_hd__fill_8_584 VSS VDD VDD sky130_fd_sc_hd__fill_8
* cell instance sky130_fd_sc_hd__fill_8_585 r0 *1 0,0
Xsky130_fd_sc_hd__fill_8_585 VSS VDD VDD sky130_fd_sc_hd__fill_8
* cell instance sky130_fd_sc_hd__fill_8_586 r0 *1 0,0
Xsky130_fd_sc_hd__fill_8_586 VSS VDD VDD sky130_fd_sc_hd__fill_8
* cell instance sky130_fd_sc_hd__fill_8_587 r0 *1 0,0
Xsky130_fd_sc_hd__fill_8_587 VSS VDD VDD sky130_fd_sc_hd__fill_8
* cell instance sky130_fd_sc_hd__fill_8_588 r0 *1 0,0
Xsky130_fd_sc_hd__fill_8_588 VSS VDD VDD sky130_fd_sc_hd__fill_8
* cell instance sky130_fd_sc_hd__fill_8_589 r0 *1 0,0
Xsky130_fd_sc_hd__fill_8_589 VSS VDD VDD sky130_fd_sc_hd__fill_8
* cell instance sky130_fd_sc_hd__fill_8_590 r0 *1 0,0
Xsky130_fd_sc_hd__fill_8_590 VSS VDD VDD sky130_fd_sc_hd__fill_8
* cell instance sky130_fd_sc_hd__fill_8_591 r0 *1 0,0
Xsky130_fd_sc_hd__fill_8_591 VSS VDD VDD sky130_fd_sc_hd__fill_8
* cell instance sky130_fd_sc_hd__fill_8_592 r0 *1 0,0
Xsky130_fd_sc_hd__fill_8_592 VSS VDD VDD sky130_fd_sc_hd__fill_8
* cell instance sky130_fd_sc_hd__fill_8_593 r0 *1 0,0
Xsky130_fd_sc_hd__fill_8_593 VSS VDD VDD sky130_fd_sc_hd__fill_8
* cell instance sky130_fd_sc_hd__fill_8_594 r0 *1 0,0
Xsky130_fd_sc_hd__fill_8_594 VSS VDD VDD sky130_fd_sc_hd__fill_8
* cell instance sky130_fd_sc_hd__fill_8_595 r0 *1 0,0
Xsky130_fd_sc_hd__fill_8_595 VSS VDD VDD sky130_fd_sc_hd__fill_8
* cell instance sky130_fd_sc_hd__fill_8_596 r0 *1 0,0
Xsky130_fd_sc_hd__fill_8_596 VSS VDD VDD sky130_fd_sc_hd__fill_8
* cell instance sky130_fd_sc_hd__fill_8_597 r0 *1 0,0
Xsky130_fd_sc_hd__fill_8_597 VSS VDD VDD sky130_fd_sc_hd__fill_8
* cell instance sky130_fd_sc_hd__fill_8_598 r0 *1 0,0
Xsky130_fd_sc_hd__fill_8_598 VSS VDD VDD sky130_fd_sc_hd__fill_8
* cell instance sky130_fd_sc_hd__fill_8_599 r0 *1 0,0
Xsky130_fd_sc_hd__fill_8_599 VSS VDD VDD sky130_fd_sc_hd__fill_8
* cell instance sky130_fd_sc_hd__fill_8_600 r0 *1 0,0
Xsky130_fd_sc_hd__fill_8_600 VSS VDD VDD sky130_fd_sc_hd__fill_8
* cell instance sky130_fd_sc_hd__fill_8_601 r0 *1 0,0
Xsky130_fd_sc_hd__fill_8_601 VSS VDD VDD sky130_fd_sc_hd__fill_8
* cell instance sky130_fd_sc_hd__fill_8_602 r0 *1 0,0
Xsky130_fd_sc_hd__fill_8_602 VSS VDD VDD sky130_fd_sc_hd__fill_8
* cell instance sky130_fd_sc_hd__fill_8_603 r0 *1 0,0
Xsky130_fd_sc_hd__fill_8_603 VSS VDD VDD sky130_fd_sc_hd__fill_8
* cell instance sky130_fd_sc_hd__fill_8_604 r0 *1 0,0
Xsky130_fd_sc_hd__fill_8_604 VSS VDD VDD sky130_fd_sc_hd__fill_8
* cell instance sky130_fd_sc_hd__fill_8_605 r0 *1 0,0
Xsky130_fd_sc_hd__fill_8_605 VSS VDD VDD sky130_fd_sc_hd__fill_8
* cell instance sky130_fd_sc_hd__fill_8_606 r0 *1 0,0
Xsky130_fd_sc_hd__fill_8_606 VSS VDD VDD sky130_fd_sc_hd__fill_8
* cell instance sky130_fd_sc_hd__fill_8_607 r0 *1 0,0
Xsky130_fd_sc_hd__fill_8_607 VSS VDD VDD sky130_fd_sc_hd__fill_8
* cell instance sky130_fd_sc_hd__fill_8_608 r0 *1 0,0
Xsky130_fd_sc_hd__fill_8_608 VSS VDD VDD sky130_fd_sc_hd__fill_8
* cell instance sky130_fd_sc_hd__fill_8_609 r0 *1 0,0
Xsky130_fd_sc_hd__fill_8_609 VSS VDD VDD sky130_fd_sc_hd__fill_8
* cell instance sky130_fd_sc_hd__fill_8_610 r0 *1 0,0
Xsky130_fd_sc_hd__fill_8_610 VSS VDD VDD sky130_fd_sc_hd__fill_8
* cell instance sky130_fd_sc_hd__fill_8_611 r0 *1 0,0
Xsky130_fd_sc_hd__fill_8_611 VSS VDD VDD sky130_fd_sc_hd__fill_8
* cell instance sky130_fd_sc_hd__fill_8_612 r0 *1 0,0
Xsky130_fd_sc_hd__fill_8_612 VSS VDD VDD sky130_fd_sc_hd__fill_8
* cell instance sky130_fd_sc_hd__fill_8_613 r0 *1 0,0
Xsky130_fd_sc_hd__fill_8_613 VSS VDD VDD sky130_fd_sc_hd__fill_8
* cell instance sky130_fd_sc_hd__fill_8_614 r0 *1 0,0
Xsky130_fd_sc_hd__fill_8_614 VSS VDD VDD sky130_fd_sc_hd__fill_8
* cell instance sky130_fd_sc_hd__fill_8_615 r0 *1 0,0
Xsky130_fd_sc_hd__fill_8_615 VSS VDD VDD sky130_fd_sc_hd__fill_8
* cell instance sky130_fd_sc_hd__fill_8_616 r0 *1 0,0
Xsky130_fd_sc_hd__fill_8_616 VSS VDD VDD sky130_fd_sc_hd__fill_8
* cell instance sky130_fd_sc_hd__fill_8_617 r0 *1 0,0
Xsky130_fd_sc_hd__fill_8_617 VSS VDD VDD sky130_fd_sc_hd__fill_8
* cell instance sky130_fd_sc_hd__fill_8_618 r0 *1 0,0
Xsky130_fd_sc_hd__fill_8_618 VSS VDD VDD sky130_fd_sc_hd__fill_8
* cell instance sky130_fd_sc_hd__fill_8_619 r0 *1 0,0
Xsky130_fd_sc_hd__fill_8_619 VSS VDD VDD sky130_fd_sc_hd__fill_8
* cell instance sky130_fd_sc_hd__fill_8_620 r0 *1 0,0
Xsky130_fd_sc_hd__fill_8_620 VSS VDD VDD sky130_fd_sc_hd__fill_8
* cell instance sky130_fd_sc_hd__fill_8_621 r0 *1 0,0
Xsky130_fd_sc_hd__fill_8_621 VSS VDD VDD sky130_fd_sc_hd__fill_8
* cell instance sky130_fd_sc_hd__fill_8_622 r0 *1 0,0
Xsky130_fd_sc_hd__fill_8_622 VSS VDD VDD sky130_fd_sc_hd__fill_8
* cell instance sky130_fd_sc_hd__fill_8_623 r0 *1 0,0
Xsky130_fd_sc_hd__fill_8_623 VSS VDD VDD sky130_fd_sc_hd__fill_8
* cell instance sky130_fd_sc_hd__fill_8_624 r0 *1 0,0
Xsky130_fd_sc_hd__fill_8_624 VSS VDD VDD sky130_fd_sc_hd__fill_8
* cell instance sky130_fd_sc_hd__fill_8_625 r0 *1 0,0
Xsky130_fd_sc_hd__fill_8_625 VSS VDD VDD sky130_fd_sc_hd__fill_8
* cell instance sky130_fd_sc_hd__fill_8_626 r0 *1 0,0
Xsky130_fd_sc_hd__fill_8_626 VSS VDD VDD sky130_fd_sc_hd__fill_8
* cell instance sky130_fd_sc_hd__fill_8_627 r0 *1 0,0
Xsky130_fd_sc_hd__fill_8_627 VSS VDD VDD sky130_fd_sc_hd__fill_8
* cell instance sky130_fd_sc_hd__fill_8_628 r0 *1 0,0
Xsky130_fd_sc_hd__fill_8_628 VSS VDD VDD sky130_fd_sc_hd__fill_8
* cell instance sky130_fd_sc_hd__fill_8_629 r0 *1 0,0
Xsky130_fd_sc_hd__fill_8_629 VSS VDD VDD sky130_fd_sc_hd__fill_8
* cell instance sky130_fd_sc_hd__fill_8_630 r0 *1 0,0
Xsky130_fd_sc_hd__fill_8_630 VSS VDD VDD sky130_fd_sc_hd__fill_8
* cell instance sky130_fd_sc_hd__fill_8_631 r0 *1 0,0
Xsky130_fd_sc_hd__fill_8_631 VSS VDD VDD sky130_fd_sc_hd__fill_8
* cell instance sky130_fd_sc_hd__fill_8_632 r0 *1 0,0
Xsky130_fd_sc_hd__fill_8_632 VSS VDD VDD sky130_fd_sc_hd__fill_8
* cell instance sky130_fd_sc_hd__fill_8_633 r0 *1 0,0
Xsky130_fd_sc_hd__fill_8_633 VSS VDD VDD sky130_fd_sc_hd__fill_8
* cell instance sky130_fd_sc_hd__fill_8_634 r0 *1 0,0
Xsky130_fd_sc_hd__fill_8_634 VSS VDD VDD sky130_fd_sc_hd__fill_8
* cell instance sky130_fd_sc_hd__fill_8_635 r0 *1 0,0
Xsky130_fd_sc_hd__fill_8_635 VSS VDD VDD sky130_fd_sc_hd__fill_8
* cell instance sky130_fd_sc_hd__fill_8_636 r0 *1 0,0
Xsky130_fd_sc_hd__fill_8_636 VSS VDD VDD sky130_fd_sc_hd__fill_8
* cell instance sky130_fd_sc_hd__fill_8_637 r0 *1 0,0
Xsky130_fd_sc_hd__fill_8_637 VSS VDD VDD sky130_fd_sc_hd__fill_8
* cell instance sky130_fd_sc_hd__fill_8_638 r0 *1 0,0
Xsky130_fd_sc_hd__fill_8_638 VSS VDD VDD sky130_fd_sc_hd__fill_8
* cell instance sky130_fd_sc_hd__fill_8_639 r0 *1 0,0
Xsky130_fd_sc_hd__fill_8_639 VSS VDD VDD sky130_fd_sc_hd__fill_8
* cell instance sky130_fd_sc_hd__fill_8_640 r0 *1 0,0
Xsky130_fd_sc_hd__fill_8_640 VSS VDD VDD sky130_fd_sc_hd__fill_8
* cell instance sky130_fd_sc_hd__fill_8_641 r0 *1 0,0
Xsky130_fd_sc_hd__fill_8_641 VSS VDD VDD sky130_fd_sc_hd__fill_8
* cell instance sky130_fd_sc_hd__fill_8_642 r0 *1 0,0
Xsky130_fd_sc_hd__fill_8_642 VSS VDD VDD sky130_fd_sc_hd__fill_8
* cell instance sky130_fd_sc_hd__fill_8_643 r0 *1 0,0
Xsky130_fd_sc_hd__fill_8_643 VSS VDD VDD sky130_fd_sc_hd__fill_8
* cell instance sky130_fd_sc_hd__fill_8_644 r0 *1 0,0
Xsky130_fd_sc_hd__fill_8_644 VSS VDD VDD sky130_fd_sc_hd__fill_8
* cell instance sky130_fd_sc_hd__fill_8_645 r0 *1 0,0
Xsky130_fd_sc_hd__fill_8_645 VSS VDD VDD sky130_fd_sc_hd__fill_8
* cell instance sky130_fd_sc_hd__fill_8_646 r0 *1 0,0
Xsky130_fd_sc_hd__fill_8_646 VSS VDD VDD sky130_fd_sc_hd__fill_8
* cell instance sky130_fd_sc_hd__fill_8_647 r0 *1 0,0
Xsky130_fd_sc_hd__fill_8_647 VSS VDD VDD sky130_fd_sc_hd__fill_8
* cell instance sky130_fd_sc_hd__fill_8_648 r0 *1 0,0
Xsky130_fd_sc_hd__fill_8_648 VSS VDD VDD sky130_fd_sc_hd__fill_8
* cell instance sky130_fd_sc_hd__fill_8_649 r0 *1 0,0
Xsky130_fd_sc_hd__fill_8_649 VSS VDD VDD sky130_fd_sc_hd__fill_8
* cell instance sky130_fd_sc_hd__fill_8_650 r0 *1 0,0
Xsky130_fd_sc_hd__fill_8_650 VSS VDD VDD sky130_fd_sc_hd__fill_8
* cell instance sky130_fd_sc_hd__fill_8_651 r0 *1 0,0
Xsky130_fd_sc_hd__fill_8_651 VSS VDD VDD sky130_fd_sc_hd__fill_8
* cell instance sky130_fd_sc_hd__fill_8_652 r0 *1 0,0
Xsky130_fd_sc_hd__fill_8_652 VSS VDD VDD sky130_fd_sc_hd__fill_8
* cell instance sky130_fd_sc_hd__fill_8_653 r0 *1 0,0
Xsky130_fd_sc_hd__fill_8_653 VSS VDD VDD sky130_fd_sc_hd__fill_8
* cell instance sky130_fd_sc_hd__fill_8_654 r0 *1 0,0
Xsky130_fd_sc_hd__fill_8_654 VSS VDD VDD sky130_fd_sc_hd__fill_8
* cell instance sky130_fd_sc_hd__fill_8_655 r0 *1 0,0
Xsky130_fd_sc_hd__fill_8_655 VSS VDD VDD sky130_fd_sc_hd__fill_8
* cell instance sky130_fd_sc_hd__fill_8_656 r0 *1 0,0
Xsky130_fd_sc_hd__fill_8_656 VSS VDD VDD sky130_fd_sc_hd__fill_8
* cell instance sky130_fd_sc_hd__fill_8_657 r0 *1 0,0
Xsky130_fd_sc_hd__fill_8_657 VSS VDD VDD sky130_fd_sc_hd__fill_8
* cell instance sky130_fd_sc_hd__fill_8_658 r0 *1 0,0
Xsky130_fd_sc_hd__fill_8_658 VSS VDD VDD sky130_fd_sc_hd__fill_8
* cell instance sky130_fd_sc_hd__fill_8_659 r0 *1 0,0
Xsky130_fd_sc_hd__fill_8_659 VSS VDD VDD sky130_fd_sc_hd__fill_8
* cell instance sky130_fd_sc_hd__fill_8_660 r0 *1 0,0
Xsky130_fd_sc_hd__fill_8_660 VSS VDD VDD sky130_fd_sc_hd__fill_8
* cell instance sky130_fd_sc_hd__fill_8_661 r0 *1 0,0
Xsky130_fd_sc_hd__fill_8_661 VSS VDD VDD sky130_fd_sc_hd__fill_8
* cell instance sky130_fd_sc_hd__fill_8_662 r0 *1 0,0
Xsky130_fd_sc_hd__fill_8_662 VSS VDD VDD sky130_fd_sc_hd__fill_8
* cell instance sky130_fd_sc_hd__fill_8_663 r0 *1 0,0
Xsky130_fd_sc_hd__fill_8_663 VSS VDD VDD sky130_fd_sc_hd__fill_8
* cell instance sky130_fd_sc_hd__fill_8_664 r0 *1 0,0
Xsky130_fd_sc_hd__fill_8_664 VSS VDD VDD sky130_fd_sc_hd__fill_8
* cell instance sky130_fd_sc_hd__fill_8_665 r0 *1 0,0
Xsky130_fd_sc_hd__fill_8_665 VSS VDD VDD sky130_fd_sc_hd__fill_8
* cell instance sky130_fd_sc_hd__fill_8_666 r0 *1 0,0
Xsky130_fd_sc_hd__fill_8_666 VSS VDD VDD sky130_fd_sc_hd__fill_8
* cell instance sky130_fd_sc_hd__fill_8_667 r0 *1 0,0
Xsky130_fd_sc_hd__fill_8_667 VSS VDD VDD sky130_fd_sc_hd__fill_8
* cell instance sky130_fd_sc_hd__fill_8_668 r0 *1 0,0
Xsky130_fd_sc_hd__fill_8_668 VSS VDD VDD sky130_fd_sc_hd__fill_8
* cell instance sky130_fd_sc_hd__fill_8_669 r0 *1 0,0
Xsky130_fd_sc_hd__fill_8_669 VSS VDD VDD sky130_fd_sc_hd__fill_8
* cell instance sky130_fd_sc_hd__fill_8_670 r0 *1 0,0
Xsky130_fd_sc_hd__fill_8_670 VSS VDD VDD sky130_fd_sc_hd__fill_8
* cell instance sky130_fd_sc_hd__fill_8_671 r0 *1 0,0
Xsky130_fd_sc_hd__fill_8_671 VSS VDD VDD sky130_fd_sc_hd__fill_8
* cell instance sky130_fd_sc_hd__fill_8_672 r0 *1 0,0
Xsky130_fd_sc_hd__fill_8_672 VSS VDD VDD sky130_fd_sc_hd__fill_8
* cell instance sky130_fd_sc_hd__fill_8_673 r0 *1 0,0
Xsky130_fd_sc_hd__fill_8_673 VSS VDD VDD sky130_fd_sc_hd__fill_8
* cell instance sky130_fd_sc_hd__fill_8_674 r0 *1 0,0
Xsky130_fd_sc_hd__fill_8_674 VSS VDD VDD sky130_fd_sc_hd__fill_8
* cell instance sky130_fd_sc_hd__fill_8_675 r0 *1 0,0
Xsky130_fd_sc_hd__fill_8_675 VSS VDD VDD sky130_fd_sc_hd__fill_8
* cell instance sky130_fd_sc_hd__fill_8_676 r0 *1 0,0
Xsky130_fd_sc_hd__fill_8_676 VSS VDD VDD sky130_fd_sc_hd__fill_8
* cell instance sky130_fd_sc_hd__fill_8_677 r0 *1 0,0
Xsky130_fd_sc_hd__fill_8_677 VSS VDD VDD sky130_fd_sc_hd__fill_8
* cell instance sky130_fd_sc_hd__fill_8_678 r0 *1 0,0
Xsky130_fd_sc_hd__fill_8_678 VSS VDD VDD sky130_fd_sc_hd__fill_8
* cell instance sky130_fd_sc_hd__fill_8_679 r0 *1 0,0
Xsky130_fd_sc_hd__fill_8_679 VSS VDD VDD sky130_fd_sc_hd__fill_8
* cell instance sky130_fd_sc_hd__fill_8_680 r0 *1 0,0
Xsky130_fd_sc_hd__fill_8_680 VSS VDD VDD sky130_fd_sc_hd__fill_8
* cell instance sky130_fd_sc_hd__fill_8_681 r0 *1 0,0
Xsky130_fd_sc_hd__fill_8_681 VSS VDD VDD sky130_fd_sc_hd__fill_8
* cell instance sky130_fd_sc_hd__fill_8_682 r0 *1 0,0
Xsky130_fd_sc_hd__fill_8_682 VSS VDD VDD sky130_fd_sc_hd__fill_8
* cell instance sky130_fd_sc_hd__fill_8_683 r0 *1 0,0
Xsky130_fd_sc_hd__fill_8_683 VSS VDD VDD sky130_fd_sc_hd__fill_8
* cell instance sky130_fd_sc_hd__fill_8_684 r0 *1 0,0
Xsky130_fd_sc_hd__fill_8_684 VSS VDD VDD sky130_fd_sc_hd__fill_8
* cell instance sky130_fd_sc_hd__fill_8_685 r0 *1 0,0
Xsky130_fd_sc_hd__fill_8_685 VSS VDD VDD sky130_fd_sc_hd__fill_8
* cell instance sky130_fd_sc_hd__fill_8_686 r0 *1 0,0
Xsky130_fd_sc_hd__fill_8_686 VSS VDD VDD sky130_fd_sc_hd__fill_8
* cell instance sky130_fd_sc_hd__fill_8_687 r0 *1 0,0
Xsky130_fd_sc_hd__fill_8_687 VSS VDD VDD sky130_fd_sc_hd__fill_8
* cell instance sky130_fd_sc_hd__fill_8_688 r0 *1 0,0
Xsky130_fd_sc_hd__fill_8_688 VSS VDD VDD sky130_fd_sc_hd__fill_8
* cell instance sky130_fd_sc_hd__fill_8_689 r0 *1 0,0
Xsky130_fd_sc_hd__fill_8_689 VSS VDD VDD sky130_fd_sc_hd__fill_8
* cell instance sky130_fd_sc_hd__fill_8_690 r0 *1 0,0
Xsky130_fd_sc_hd__fill_8_690 VSS VDD VDD sky130_fd_sc_hd__fill_8
* cell instance sky130_fd_sc_hd__fill_8_691 r0 *1 0,0
Xsky130_fd_sc_hd__fill_8_691 VSS VDD VDD sky130_fd_sc_hd__fill_8
* cell instance sky130_fd_sc_hd__fill_8_692 r0 *1 0,0
Xsky130_fd_sc_hd__fill_8_692 VSS VDD VDD sky130_fd_sc_hd__fill_8
* cell instance sky130_fd_sc_hd__fill_8_693 r0 *1 0,0
Xsky130_fd_sc_hd__fill_8_693 VSS VDD VDD sky130_fd_sc_hd__fill_8
* cell instance sky130_fd_sc_hd__fill_8_694 r0 *1 0,0
Xsky130_fd_sc_hd__fill_8_694 VSS VDD VDD sky130_fd_sc_hd__fill_8
* cell instance sky130_fd_sc_hd__fill_8_695 r0 *1 0,0
Xsky130_fd_sc_hd__fill_8_695 VSS VDD VDD sky130_fd_sc_hd__fill_8
* cell instance sky130_fd_sc_hd__fill_8_696 r0 *1 0,0
Xsky130_fd_sc_hd__fill_8_696 VSS VDD VDD sky130_fd_sc_hd__fill_8
* cell instance sky130_fd_sc_hd__fill_8_697 r0 *1 0,0
Xsky130_fd_sc_hd__fill_8_697 VSS VDD VDD sky130_fd_sc_hd__fill_8
* cell instance sky130_fd_sc_hd__fill_8_698 r0 *1 0,0
Xsky130_fd_sc_hd__fill_8_698 VSS VDD VDD sky130_fd_sc_hd__fill_8
* cell instance sky130_fd_sc_hd__fill_8_699 r0 *1 0,0
Xsky130_fd_sc_hd__fill_8_699 VSS VDD VDD sky130_fd_sc_hd__fill_8
* cell instance sky130_fd_sc_hd__fill_8_700 r0 *1 0,0
Xsky130_fd_sc_hd__fill_8_700 VSS VDD VDD sky130_fd_sc_hd__fill_8
* cell instance sky130_fd_sc_hd__fill_8_701 r0 *1 0,0
Xsky130_fd_sc_hd__fill_8_701 VSS VDD VDD sky130_fd_sc_hd__fill_8
* cell instance sky130_fd_sc_hd__fill_8_702 r0 *1 0,0
Xsky130_fd_sc_hd__fill_8_702 VSS VDD VDD sky130_fd_sc_hd__fill_8
* cell instance sky130_fd_sc_hd__fill_8_703 r0 *1 0,0
Xsky130_fd_sc_hd__fill_8_703 VSS VDD VDD sky130_fd_sc_hd__fill_8
* cell instance sky130_fd_sc_hd__fill_8_704 r0 *1 0,0
Xsky130_fd_sc_hd__fill_8_704 VSS VDD VDD sky130_fd_sc_hd__fill_8
* cell instance sky130_fd_sc_hd__fill_8_705 r0 *1 0,0
Xsky130_fd_sc_hd__fill_8_705 VSS VDD VDD sky130_fd_sc_hd__fill_8
* cell instance sky130_fd_sc_hd__fill_8_706 r0 *1 0,0
Xsky130_fd_sc_hd__fill_8_706 VSS VDD VDD sky130_fd_sc_hd__fill_8
* cell instance sky130_fd_sc_hd__fill_8_707 r0 *1 0,0
Xsky130_fd_sc_hd__fill_8_707 VSS VDD VDD sky130_fd_sc_hd__fill_8
* cell instance sky130_fd_sc_hd__fill_8_708 r0 *1 0,0
Xsky130_fd_sc_hd__fill_8_708 VSS VDD VDD sky130_fd_sc_hd__fill_8
* cell instance sky130_fd_sc_hd__fill_8_709 r0 *1 0,0
Xsky130_fd_sc_hd__fill_8_709 VSS VDD VDD sky130_fd_sc_hd__fill_8
* cell instance sky130_fd_sc_hd__fill_8_710 r0 *1 0,0
Xsky130_fd_sc_hd__fill_8_710 VSS VDD VDD sky130_fd_sc_hd__fill_8
* cell instance sky130_fd_sc_hd__fill_8_711 r0 *1 0,0
Xsky130_fd_sc_hd__fill_8_711 VSS VDD VDD sky130_fd_sc_hd__fill_8
* cell instance sky130_fd_sc_hd__fill_8_712 r0 *1 0,0
Xsky130_fd_sc_hd__fill_8_712 VSS VDD VDD sky130_fd_sc_hd__fill_8
* cell instance sky130_fd_sc_hd__fill_8_713 r0 *1 0,0
Xsky130_fd_sc_hd__fill_8_713 VSS VDD VDD sky130_fd_sc_hd__fill_8
* cell instance sky130_fd_sc_hd__fill_8_714 r0 *1 0,0
Xsky130_fd_sc_hd__fill_8_714 VSS VDD VDD sky130_fd_sc_hd__fill_8
* cell instance sky130_fd_sc_hd__fill_8_715 r0 *1 0,0
Xsky130_fd_sc_hd__fill_8_715 VSS VDD VDD sky130_fd_sc_hd__fill_8
* cell instance sky130_fd_sc_hd__fill_8_716 r0 *1 0,0
Xsky130_fd_sc_hd__fill_8_716 VSS VDD VDD sky130_fd_sc_hd__fill_8
* cell instance sky130_fd_sc_hd__fill_8_717 r0 *1 0,0
Xsky130_fd_sc_hd__fill_8_717 VSS VDD VDD sky130_fd_sc_hd__fill_8
* cell instance sky130_fd_sc_hd__fill_8_718 r0 *1 0,0
Xsky130_fd_sc_hd__fill_8_718 VSS VDD VDD sky130_fd_sc_hd__fill_8
* cell instance sky130_fd_sc_hd__fill_8_719 r0 *1 0,0
Xsky130_fd_sc_hd__fill_8_719 VSS VDD VDD sky130_fd_sc_hd__fill_8
* cell instance sky130_fd_sc_hd__fill_8_720 r0 *1 0,0
Xsky130_fd_sc_hd__fill_8_720 VSS VDD VDD sky130_fd_sc_hd__fill_8
* cell instance sky130_fd_sc_hd__fill_8_721 r0 *1 0,0
Xsky130_fd_sc_hd__fill_8_721 VSS VDD VDD sky130_fd_sc_hd__fill_8
* cell instance sky130_fd_sc_hd__fill_8_722 r0 *1 0,0
Xsky130_fd_sc_hd__fill_8_722 VSS VDD VDD sky130_fd_sc_hd__fill_8
* cell instance sky130_fd_sc_hd__fill_8_723 r0 *1 0,0
Xsky130_fd_sc_hd__fill_8_723 VSS VDD VDD sky130_fd_sc_hd__fill_8
* cell instance sky130_fd_sc_hd__fill_8_724 r0 *1 0,0
Xsky130_fd_sc_hd__fill_8_724 VSS VDD VDD sky130_fd_sc_hd__fill_8
* cell instance sky130_fd_sc_hd__fill_8_725 r0 *1 0,0
Xsky130_fd_sc_hd__fill_8_725 VSS VDD VDD sky130_fd_sc_hd__fill_8
* cell instance sky130_fd_sc_hd__fill_8_726 r0 *1 0,0
Xsky130_fd_sc_hd__fill_8_726 VSS VDD VDD sky130_fd_sc_hd__fill_8
* cell instance sky130_fd_sc_hd__fill_8_727 r0 *1 0,0
Xsky130_fd_sc_hd__fill_8_727 VSS VDD VDD sky130_fd_sc_hd__fill_8
* cell instance sky130_fd_sc_hd__fill_8_728 r0 *1 0,0
Xsky130_fd_sc_hd__fill_8_728 VSS VDD VDD sky130_fd_sc_hd__fill_8
* cell instance sky130_fd_sc_hd__fill_8_729 r0 *1 0,0
Xsky130_fd_sc_hd__fill_8_729 VSS VDD VDD sky130_fd_sc_hd__fill_8
* cell instance sky130_fd_sc_hd__fill_8_730 r0 *1 0,0
Xsky130_fd_sc_hd__fill_8_730 VSS VDD VDD sky130_fd_sc_hd__fill_8
* cell instance sky130_fd_sc_hd__fill_8_731 r0 *1 0,0
Xsky130_fd_sc_hd__fill_8_731 VSS VDD VDD sky130_fd_sc_hd__fill_8
* cell instance sky130_fd_sc_hd__fill_8_732 r0 *1 0,0
Xsky130_fd_sc_hd__fill_8_732 VSS VDD VDD sky130_fd_sc_hd__fill_8
* cell instance sky130_fd_sc_hd__fill_8_733 r0 *1 0,0
Xsky130_fd_sc_hd__fill_8_733 VSS VDD VDD sky130_fd_sc_hd__fill_8
* cell instance sky130_fd_sc_hd__fill_8_734 r0 *1 0,0
Xsky130_fd_sc_hd__fill_8_734 VSS VDD VDD sky130_fd_sc_hd__fill_8
* cell instance sky130_fd_sc_hd__fill_8_735 r0 *1 0,0
Xsky130_fd_sc_hd__fill_8_735 VSS VDD VDD sky130_fd_sc_hd__fill_8
* cell instance sky130_fd_sc_hd__fill_8_736 r0 *1 0,0
Xsky130_fd_sc_hd__fill_8_736 VSS VDD VDD sky130_fd_sc_hd__fill_8
* cell instance sky130_fd_sc_hd__fill_8_737 r0 *1 0,0
Xsky130_fd_sc_hd__fill_8_737 VSS VDD VDD sky130_fd_sc_hd__fill_8
* cell instance sky130_fd_sc_hd__fill_8_738 r0 *1 0,0
Xsky130_fd_sc_hd__fill_8_738 VSS VDD VDD sky130_fd_sc_hd__fill_8
* cell instance sky130_fd_sc_hd__fill_8_739 r0 *1 0,0
Xsky130_fd_sc_hd__fill_8_739 VSS VDD VDD sky130_fd_sc_hd__fill_8
* cell instance sky130_fd_sc_hd__fill_8_740 r0 *1 0,0
Xsky130_fd_sc_hd__fill_8_740 VSS VDD VDD sky130_fd_sc_hd__fill_8
* cell instance sky130_fd_sc_hd__fill_8_741 r0 *1 0,0
Xsky130_fd_sc_hd__fill_8_741 VSS VDD VDD sky130_fd_sc_hd__fill_8
* cell instance sky130_fd_sc_hd__fill_8_742 r0 *1 0,0
Xsky130_fd_sc_hd__fill_8_742 VSS VDD VDD sky130_fd_sc_hd__fill_8
* cell instance sky130_fd_sc_hd__fill_8_743 r0 *1 0,0
Xsky130_fd_sc_hd__fill_8_743 VSS VDD VDD sky130_fd_sc_hd__fill_8
* cell instance sky130_fd_sc_hd__fill_8_744 r0 *1 0,0
Xsky130_fd_sc_hd__fill_8_744 VSS VDD VDD sky130_fd_sc_hd__fill_8
* cell instance sky130_fd_sc_hd__fill_8_745 r0 *1 0,0
Xsky130_fd_sc_hd__fill_8_745 VSS VDD VDD sky130_fd_sc_hd__fill_8
* cell instance sky130_fd_sc_hd__fill_8_746 r0 *1 0,0
Xsky130_fd_sc_hd__fill_8_746 VSS VDD VDD sky130_fd_sc_hd__fill_8
* cell instance sky130_fd_sc_hd__fill_8_747 r0 *1 0,0
Xsky130_fd_sc_hd__fill_8_747 VSS VDD VDD sky130_fd_sc_hd__fill_8
* cell instance sky130_fd_sc_hd__fill_8_748 r0 *1 0,0
Xsky130_fd_sc_hd__fill_8_748 VSS VDD VDD sky130_fd_sc_hd__fill_8
* cell instance sky130_fd_sc_hd__fill_8_749 r0 *1 0,0
Xsky130_fd_sc_hd__fill_8_749 VSS VDD VDD sky130_fd_sc_hd__fill_8
* cell instance sky130_fd_sc_hd__fill_8_750 r0 *1 0,0
Xsky130_fd_sc_hd__fill_8_750 VSS VDD VDD sky130_fd_sc_hd__fill_8
* cell instance sky130_fd_sc_hd__fill_8_751 r0 *1 0,0
Xsky130_fd_sc_hd__fill_8_751 VSS VDD VDD sky130_fd_sc_hd__fill_8
* cell instance sky130_fd_sc_hd__fill_8_752 r0 *1 0,0
Xsky130_fd_sc_hd__fill_8_752 VSS VDD VDD sky130_fd_sc_hd__fill_8
* cell instance sky130_fd_sc_hd__fill_8_753 r0 *1 0,0
Xsky130_fd_sc_hd__fill_8_753 VSS VDD VDD sky130_fd_sc_hd__fill_8
* cell instance sky130_fd_sc_hd__fill_8_754 r0 *1 0,0
Xsky130_fd_sc_hd__fill_8_754 VSS VDD VDD sky130_fd_sc_hd__fill_8
* cell instance sky130_fd_sc_hd__fill_8_755 r0 *1 0,0
Xsky130_fd_sc_hd__fill_8_755 VSS VDD VDD sky130_fd_sc_hd__fill_8
* cell instance sky130_fd_sc_hd__fill_8_756 r0 *1 0,0
Xsky130_fd_sc_hd__fill_8_756 VSS VDD VDD sky130_fd_sc_hd__fill_8
* cell instance sky130_fd_sc_hd__fill_8_757 r0 *1 0,0
Xsky130_fd_sc_hd__fill_8_757 VSS VDD VDD sky130_fd_sc_hd__fill_8
* cell instance sky130_fd_sc_hd__fill_8_758 r0 *1 0,0
Xsky130_fd_sc_hd__fill_8_758 VSS VDD VDD sky130_fd_sc_hd__fill_8
* cell instance sky130_fd_sc_hd__fill_8_759 r0 *1 0,0
Xsky130_fd_sc_hd__fill_8_759 VSS VDD VDD sky130_fd_sc_hd__fill_8
* cell instance sky130_fd_sc_hd__fill_8_760 r0 *1 0,0
Xsky130_fd_sc_hd__fill_8_760 VSS VDD VDD sky130_fd_sc_hd__fill_8
* cell instance sky130_fd_sc_hd__fill_8_761 r0 *1 0,0
Xsky130_fd_sc_hd__fill_8_761 VSS VDD VDD sky130_fd_sc_hd__fill_8
* cell instance sky130_fd_sc_hd__fill_8_762 r0 *1 0,0
Xsky130_fd_sc_hd__fill_8_762 VSS VDD VDD sky130_fd_sc_hd__fill_8
* cell instance sky130_fd_sc_hd__fill_8_763 r0 *1 0,0
Xsky130_fd_sc_hd__fill_8_763 VSS VDD VDD sky130_fd_sc_hd__fill_8
* cell instance sky130_fd_sc_hd__fill_8_764 r0 *1 0,0
Xsky130_fd_sc_hd__fill_8_764 VSS VDD VDD sky130_fd_sc_hd__fill_8
* cell instance sky130_fd_sc_hd__fill_8_765 r0 *1 0,0
Xsky130_fd_sc_hd__fill_8_765 VSS VDD VDD sky130_fd_sc_hd__fill_8
* cell instance sky130_fd_sc_hd__fill_8_766 r0 *1 0,0
Xsky130_fd_sc_hd__fill_8_766 VSS VDD VDD sky130_fd_sc_hd__fill_8
* cell instance sky130_fd_sc_hd__fill_8_767 r0 *1 0,0
Xsky130_fd_sc_hd__fill_8_767 VSS VDD VDD sky130_fd_sc_hd__fill_8
* cell instance sky130_fd_sc_hd__fill_8_768 r0 *1 0,0
Xsky130_fd_sc_hd__fill_8_768 VSS VDD VDD sky130_fd_sc_hd__fill_8
* cell instance sky130_fd_sc_hd__fill_8_769 r0 *1 0,0
Xsky130_fd_sc_hd__fill_8_769 VSS VDD VDD sky130_fd_sc_hd__fill_8
* cell instance sky130_fd_sc_hd__fill_8_770 r0 *1 0,0
Xsky130_fd_sc_hd__fill_8_770 VSS VDD VDD sky130_fd_sc_hd__fill_8
* cell instance sky130_fd_sc_hd__fill_8_771 r0 *1 0,0
Xsky130_fd_sc_hd__fill_8_771 VSS VDD VDD sky130_fd_sc_hd__fill_8
* cell instance sky130_fd_sc_hd__fill_8_772 r0 *1 0,0
Xsky130_fd_sc_hd__fill_8_772 VSS VDD VDD sky130_fd_sc_hd__fill_8
* cell instance sky130_fd_sc_hd__fill_8_773 r0 *1 0,0
Xsky130_fd_sc_hd__fill_8_773 VSS VDD VDD sky130_fd_sc_hd__fill_8
* cell instance sky130_fd_sc_hd__fill_8_774 r0 *1 0,0
Xsky130_fd_sc_hd__fill_8_774 VSS VDD VDD sky130_fd_sc_hd__fill_8
* cell instance sky130_fd_sc_hd__fill_8_775 r0 *1 0,0
Xsky130_fd_sc_hd__fill_8_775 VSS VDD VDD sky130_fd_sc_hd__fill_8
* cell instance sky130_fd_sc_hd__fill_8_776 r0 *1 0,0
Xsky130_fd_sc_hd__fill_8_776 VSS VDD VDD sky130_fd_sc_hd__fill_8
* cell instance sky130_fd_sc_hd__fill_8_777 r0 *1 0,0
Xsky130_fd_sc_hd__fill_8_777 VSS VDD VDD sky130_fd_sc_hd__fill_8
* cell instance sky130_fd_sc_hd__fill_8_778 r0 *1 0,0
Xsky130_fd_sc_hd__fill_8_778 VSS VDD VDD sky130_fd_sc_hd__fill_8
* cell instance sky130_fd_sc_hd__fill_8_779 r0 *1 0,0
Xsky130_fd_sc_hd__fill_8_779 VSS VDD VDD sky130_fd_sc_hd__fill_8
* cell instance sky130_fd_sc_hd__fill_8_780 r0 *1 0,0
Xsky130_fd_sc_hd__fill_8_780 VSS VDD VDD sky130_fd_sc_hd__fill_8
* cell instance sky130_fd_sc_hd__fill_8_781 r0 *1 0,0
Xsky130_fd_sc_hd__fill_8_781 VSS VDD VDD sky130_fd_sc_hd__fill_8
* cell instance sky130_fd_sc_hd__fill_8_782 r0 *1 0,0
Xsky130_fd_sc_hd__fill_8_782 VSS VDD VDD sky130_fd_sc_hd__fill_8
* cell instance sky130_fd_sc_hd__fill_8_783 r0 *1 0,0
Xsky130_fd_sc_hd__fill_8_783 VSS VDD VDD sky130_fd_sc_hd__fill_8
* cell instance sky130_fd_sc_hd__fill_8_784 r0 *1 0,0
Xsky130_fd_sc_hd__fill_8_784 VSS VDD VDD sky130_fd_sc_hd__fill_8
* cell instance sky130_fd_sc_hd__fill_8_785 r0 *1 0,0
Xsky130_fd_sc_hd__fill_8_785 VSS VDD VDD sky130_fd_sc_hd__fill_8
* cell instance sky130_fd_sc_hd__fill_8_786 r0 *1 0,0
Xsky130_fd_sc_hd__fill_8_786 VSS VDD VDD sky130_fd_sc_hd__fill_8
* cell instance sky130_fd_sc_hd__fill_8_787 r0 *1 0,0
Xsky130_fd_sc_hd__fill_8_787 VSS VDD VDD sky130_fd_sc_hd__fill_8
* cell instance sky130_fd_sc_hd__fill_8_788 r0 *1 0,0
Xsky130_fd_sc_hd__fill_8_788 VSS VDD VDD sky130_fd_sc_hd__fill_8
* cell instance sky130_fd_sc_hd__fill_8_789 r0 *1 0,0
Xsky130_fd_sc_hd__fill_8_789 VSS VDD VDD sky130_fd_sc_hd__fill_8
* cell instance sky130_fd_sc_hd__fill_8_790 r0 *1 0,0
Xsky130_fd_sc_hd__fill_8_790 VSS VDD VDD sky130_fd_sc_hd__fill_8
* cell instance sky130_fd_sc_hd__fill_8_791 r0 *1 0,0
Xsky130_fd_sc_hd__fill_8_791 VSS VDD VDD sky130_fd_sc_hd__fill_8
* cell instance sky130_fd_sc_hd__fill_8_792 r0 *1 0,0
Xsky130_fd_sc_hd__fill_8_792 VSS VDD VDD sky130_fd_sc_hd__fill_8
* cell instance sky130_fd_sc_hd__fill_8_793 r0 *1 0,0
Xsky130_fd_sc_hd__fill_8_793 VSS VDD VDD sky130_fd_sc_hd__fill_8
* cell instance sky130_fd_sc_hd__fill_8_794 r0 *1 0,0
Xsky130_fd_sc_hd__fill_8_794 VSS VDD VDD sky130_fd_sc_hd__fill_8
* cell instance sky130_fd_sc_hd__fill_8_795 r0 *1 0,0
Xsky130_fd_sc_hd__fill_8_795 VSS VDD VDD sky130_fd_sc_hd__fill_8
* cell instance sky130_fd_sc_hd__fill_8_796 r0 *1 0,0
Xsky130_fd_sc_hd__fill_8_796 VSS VDD VDD sky130_fd_sc_hd__fill_8
* cell instance sky130_fd_sc_hd__fill_8_797 r0 *1 0,0
Xsky130_fd_sc_hd__fill_8_797 VSS VDD VDD sky130_fd_sc_hd__fill_8
* cell instance sky130_fd_sc_hd__fill_8_798 r0 *1 0,0
Xsky130_fd_sc_hd__fill_8_798 VSS VDD VDD sky130_fd_sc_hd__fill_8
* cell instance sky130_fd_sc_hd__fill_8_799 r0 *1 0,0
Xsky130_fd_sc_hd__fill_8_799 VSS VDD VDD sky130_fd_sc_hd__fill_8
* cell instance sky130_fd_sc_hd__fill_8_800 r0 *1 0,0
Xsky130_fd_sc_hd__fill_8_800 VSS VDD VDD sky130_fd_sc_hd__fill_8
* cell instance sky130_fd_sc_hd__fill_8_801 r0 *1 0,0
Xsky130_fd_sc_hd__fill_8_801 VSS VDD VDD sky130_fd_sc_hd__fill_8
* cell instance sky130_fd_sc_hd__fill_8_802 r0 *1 0,0
Xsky130_fd_sc_hd__fill_8_802 VSS VDD VDD sky130_fd_sc_hd__fill_8
* cell instance sky130_fd_sc_hd__fill_8_803 r0 *1 0,0
Xsky130_fd_sc_hd__fill_8_803 VSS VDD VDD sky130_fd_sc_hd__fill_8
* cell instance sky130_fd_sc_hd__fill_8_804 r0 *1 0,0
Xsky130_fd_sc_hd__fill_8_804 VSS VDD VDD sky130_fd_sc_hd__fill_8
* cell instance sky130_fd_sc_hd__fill_8_805 r0 *1 0,0
Xsky130_fd_sc_hd__fill_8_805 VSS VDD VDD sky130_fd_sc_hd__fill_8
* cell instance sky130_fd_sc_hd__fill_8_806 r0 *1 0,0
Xsky130_fd_sc_hd__fill_8_806 VSS VDD VDD sky130_fd_sc_hd__fill_8
* cell instance sky130_fd_sc_hd__fill_8_807 r0 *1 0,0
Xsky130_fd_sc_hd__fill_8_807 VSS VDD VDD sky130_fd_sc_hd__fill_8
* cell instance sky130_fd_sc_hd__fill_8_808 r0 *1 0,0
Xsky130_fd_sc_hd__fill_8_808 VSS VDD VDD sky130_fd_sc_hd__fill_8
* cell instance sky130_fd_sc_hd__fill_8_809 r0 *1 0,0
Xsky130_fd_sc_hd__fill_8_809 VSS VDD VDD sky130_fd_sc_hd__fill_8
* cell instance sky130_fd_sc_hd__fill_8_810 r0 *1 0,0
Xsky130_fd_sc_hd__fill_8_810 VSS VDD VDD sky130_fd_sc_hd__fill_8
* cell instance sky130_fd_sc_hd__fill_8_811 r0 *1 0,0
Xsky130_fd_sc_hd__fill_8_811 VSS VDD VDD sky130_fd_sc_hd__fill_8
* cell instance sky130_fd_sc_hd__fill_8_812 r0 *1 0,0
Xsky130_fd_sc_hd__fill_8_812 VSS VDD VDD sky130_fd_sc_hd__fill_8
* cell instance sky130_fd_sc_hd__fill_8_813 r0 *1 0,0
Xsky130_fd_sc_hd__fill_8_813 VSS VDD VDD sky130_fd_sc_hd__fill_8
* cell instance sky130_fd_sc_hd__fill_8_814 r0 *1 0,0
Xsky130_fd_sc_hd__fill_8_814 VSS VDD VDD sky130_fd_sc_hd__fill_8
* cell instance sky130_fd_sc_hd__fill_8_815 r0 *1 0,0
Xsky130_fd_sc_hd__fill_8_815 VSS VDD VDD sky130_fd_sc_hd__fill_8
* cell instance sky130_fd_sc_hd__fill_8_816 r0 *1 0,0
Xsky130_fd_sc_hd__fill_8_816 VSS VDD VDD sky130_fd_sc_hd__fill_8
* cell instance sky130_fd_sc_hd__fill_8_817 r0 *1 0,0
Xsky130_fd_sc_hd__fill_8_817 VSS VDD VDD sky130_fd_sc_hd__fill_8
* cell instance sky130_fd_sc_hd__fill_8_818 r0 *1 0,0
Xsky130_fd_sc_hd__fill_8_818 VSS VDD VDD sky130_fd_sc_hd__fill_8
* cell instance sky130_fd_sc_hd__fill_8_819 r0 *1 0,0
Xsky130_fd_sc_hd__fill_8_819 VSS VDD VDD sky130_fd_sc_hd__fill_8
* cell instance sky130_fd_sc_hd__fill_8_820 r0 *1 0,0
Xsky130_fd_sc_hd__fill_8_820 VSS VDD VDD sky130_fd_sc_hd__fill_8
* cell instance sky130_fd_sc_hd__fill_8_821 r0 *1 0,0
Xsky130_fd_sc_hd__fill_8_821 VSS VDD VDD sky130_fd_sc_hd__fill_8
* cell instance sky130_fd_sc_hd__fill_8_822 r0 *1 0,0
Xsky130_fd_sc_hd__fill_8_822 VSS VDD VDD sky130_fd_sc_hd__fill_8
* cell instance sky130_fd_sc_hd__fill_8_823 r0 *1 0,0
Xsky130_fd_sc_hd__fill_8_823 VSS VDD VDD sky130_fd_sc_hd__fill_8
* cell instance sky130_fd_sc_hd__fill_8_824 r0 *1 0,0
Xsky130_fd_sc_hd__fill_8_824 VSS VDD VDD sky130_fd_sc_hd__fill_8
* cell instance sky130_fd_sc_hd__fill_8_825 r0 *1 0,0
Xsky130_fd_sc_hd__fill_8_825 VSS VDD VDD sky130_fd_sc_hd__fill_8
* cell instance sky130_fd_sc_hd__fill_8_826 r0 *1 0,0
Xsky130_fd_sc_hd__fill_8_826 VSS VDD VDD sky130_fd_sc_hd__fill_8
* cell instance sky130_fd_sc_hd__fill_8_827 r0 *1 0,0
Xsky130_fd_sc_hd__fill_8_827 VSS VDD VDD sky130_fd_sc_hd__fill_8
* cell instance sky130_fd_sc_hd__fill_8_828 r0 *1 0,0
Xsky130_fd_sc_hd__fill_8_828 VSS VDD VDD sky130_fd_sc_hd__fill_8
* cell instance sky130_fd_sc_hd__fill_8_829 r0 *1 0,0
Xsky130_fd_sc_hd__fill_8_829 VSS VDD VDD sky130_fd_sc_hd__fill_8
* cell instance sky130_fd_sc_hd__fill_8_830 r0 *1 0,0
Xsky130_fd_sc_hd__fill_8_830 VSS VDD VDD sky130_fd_sc_hd__fill_8
* cell instance sky130_fd_sc_hd__fill_8_831 r0 *1 0,0
Xsky130_fd_sc_hd__fill_8_831 VSS VDD VDD sky130_fd_sc_hd__fill_8
* cell instance sky130_fd_sc_hd__fill_8_832 r0 *1 0,0
Xsky130_fd_sc_hd__fill_8_832 VSS VDD VDD sky130_fd_sc_hd__fill_8
* cell instance sky130_fd_sc_hd__fill_8_833 r0 *1 0,0
Xsky130_fd_sc_hd__fill_8_833 VSS VDD VDD sky130_fd_sc_hd__fill_8
* cell instance sky130_fd_sc_hd__fill_8_834 r0 *1 0,0
Xsky130_fd_sc_hd__fill_8_834 VSS VDD VDD sky130_fd_sc_hd__fill_8
* cell instance sky130_fd_sc_hd__fill_8_835 r0 *1 0,0
Xsky130_fd_sc_hd__fill_8_835 VSS VDD VDD sky130_fd_sc_hd__fill_8
* cell instance sky130_fd_sc_hd__fill_8_836 r0 *1 0,0
Xsky130_fd_sc_hd__fill_8_836 VSS VDD VDD sky130_fd_sc_hd__fill_8
* cell instance sky130_fd_sc_hd__fill_8_837 r0 *1 0,0
Xsky130_fd_sc_hd__fill_8_837 VSS VDD VDD sky130_fd_sc_hd__fill_8
* cell instance sky130_fd_sc_hd__fill_8_838 r0 *1 0,0
Xsky130_fd_sc_hd__fill_8_838 VSS VDD VDD sky130_fd_sc_hd__fill_8
* cell instance sky130_fd_sc_hd__fill_8_839 r0 *1 0,0
Xsky130_fd_sc_hd__fill_8_839 VSS VDD VDD sky130_fd_sc_hd__fill_8
* cell instance sky130_fd_sc_hd__fill_8_840 r0 *1 0,0
Xsky130_fd_sc_hd__fill_8_840 VSS VDD VDD sky130_fd_sc_hd__fill_8
* cell instance sky130_fd_sc_hd__fill_8_841 r0 *1 0,0
Xsky130_fd_sc_hd__fill_8_841 VSS VDD VDD sky130_fd_sc_hd__fill_8
* cell instance sky130_fd_sc_hd__fill_8_842 r0 *1 0,0
Xsky130_fd_sc_hd__fill_8_842 VSS VDD VDD sky130_fd_sc_hd__fill_8
* cell instance sky130_fd_sc_hd__fill_8_843 r0 *1 0,0
Xsky130_fd_sc_hd__fill_8_843 VSS VDD VDD sky130_fd_sc_hd__fill_8
* cell instance sky130_fd_sc_hd__fill_8_844 r0 *1 0,0
Xsky130_fd_sc_hd__fill_8_844 VSS VDD VDD sky130_fd_sc_hd__fill_8
* cell instance sky130_fd_sc_hd__inv_1_0 r0 *1 0,0
Xsky130_fd_sc_hd__inv_1_0 clknet_4_0_0_clk VSS VDD VDD \$678
+ sky130_fd_sc_hd__inv_1
* cell instance sky130_fd_sc_hd__inv_1_1 r0 *1 0,0
Xsky130_fd_sc_hd__inv_1_1 clknet_4_11_0_clk VSS VDD VDD \$737
+ sky130_fd_sc_hd__inv_1
* cell instance sky130_fd_sc_hd__inv_6_0 r0 *1 0,0
Xsky130_fd_sc_hd__inv_6_0 clknet_4_5_0_clk VSS VDD VDD \$1785
+ sky130_fd_sc_hd__inv_6
* cell instance sky130_fd_sc_hd__lpflow_inputiso1p_1_0 r0 *1 0,0
Xsky130_fd_sc_hd__lpflow_inputiso1p_1_0 \_0000_ \_0442_ VSS VDD VDD \_0509_
+ sky130_fd_sc_hd__lpflow_inputiso1p_1
* cell instance sky130_fd_sc_hd__lpflow_inputiso1p_1_1 r0 *1 0,0
Xsky130_fd_sc_hd__lpflow_inputiso1p_1_1 \_0307_ \_0320_ VSS VDD VDD \_0321_
+ sky130_fd_sc_hd__lpflow_inputiso1p_1
* cell instance sky130_fd_sc_hd__lpflow_inputiso1p_1_2 r0 *1 0,0
Xsky130_fd_sc_hd__lpflow_inputiso1p_1_2 \_0207_ \_0249_ VSS VDD VDD \_0250_
+ sky130_fd_sc_hd__lpflow_inputiso1p_1
* cell instance sky130_fd_sc_hd__lpflow_inputiso1p_1_3 r0 *1 0,0
Xsky130_fd_sc_hd__lpflow_inputiso1p_1_3 mod_r[6] \_0242_ VSS VDD VDD \_0243_
+ sky130_fd_sc_hd__lpflow_inputiso1p_1
* cell instance sky130_fd_sc_hd__lpflow_inputiso1p_1_4 r0 *1 0,0
Xsky130_fd_sc_hd__lpflow_inputiso1p_1_4 \_0329_ \_0378_ VSS VDD VDD \_0379_
+ sky130_fd_sc_hd__lpflow_inputiso1p_1
* cell instance sky130_fd_sc_hd__lpflow_inputiso1p_1_5 r0 *1 0,0
Xsky130_fd_sc_hd__lpflow_inputiso1p_1_5 mod_r[9] \_0237_ VSS VDD VDD \_0297_
+ sky130_fd_sc_hd__lpflow_inputiso1p_1
* cell instance sky130_fd_sc_hd__lpflow_inputiso1p_1_6 r0 *1 0,0
Xsky130_fd_sc_hd__lpflow_inputiso1p_1_6 mod_r[9] \_0234_ VSS VDD VDD \_0236_
+ sky130_fd_sc_hd__lpflow_inputiso1p_1
* cell instance sky130_fd_sc_hd__lpflow_inputiso1p_1_7 r0 *1 0,0
Xsky130_fd_sc_hd__lpflow_inputiso1p_1_7 mod_r[10] \_0232_ VSS VDD VDD \_0233_
+ sky130_fd_sc_hd__lpflow_inputiso1p_1
* cell instance sky130_fd_sc_hd__lpflow_inputiso1p_1_8 r0 *1 0,0
Xsky130_fd_sc_hd__lpflow_inputiso1p_1_8 \_0293_ \_0335_ VSS VDD VDD \_0336_
+ sky130_fd_sc_hd__lpflow_inputiso1p_1
* cell instance sky130_fd_sc_hd__lpflow_inputiso1p_1_9 r0 *1 0,0
Xsky130_fd_sc_hd__lpflow_inputiso1p_1_9 mod_r[13] \_0227_ VSS VDD VDD \_0292_
+ sky130_fd_sc_hd__lpflow_inputiso1p_1
* cell instance sky130_fd_sc_hd__lpflow_inputiso1p_1_10 r0 *1 0,0
Xsky130_fd_sc_hd__lpflow_inputiso1p_1_10 mod_r[13] \_0225_ VSS VDD VDD \_0226_
+ sky130_fd_sc_hd__lpflow_inputiso1p_1
* cell instance sky130_fd_sc_hd__lpflow_isobufsrc_1_0 r0 *1 0,0
Xsky130_fd_sc_hd__lpflow_isobufsrc_1_0 state[2] \_0138_ VSS VDD VDD \_0001_
+ sky130_fd_sc_hd__lpflow_isobufsrc_1
* cell instance sky130_fd_sc_hd__lpflow_isobufsrc_1_1 r0 *1 0,0
Xsky130_fd_sc_hd__lpflow_isobufsrc_1_1 state[3] state[2] VSS VDD VDD \_0145_
+ sky130_fd_sc_hd__lpflow_isobufsrc_1
* cell instance sky130_fd_sc_hd__lpflow_isobufsrc_1_2 r0 *1 0,0
Xsky130_fd_sc_hd__lpflow_isobufsrc_1_2 \_0316_ \_0315_ VSS VDD VDD \_0317_
+ sky130_fd_sc_hd__lpflow_isobufsrc_1
* cell instance sky130_fd_sc_hd__lpflow_isobufsrc_1_3 r0 *1 0,0
Xsky130_fd_sc_hd__lpflow_isobufsrc_1_3 mod_r[5] \_0246_ VSS VDD VDD \_0248_
+ sky130_fd_sc_hd__lpflow_isobufsrc_1
* cell instance sky130_fd_sc_hd__lpflow_isobufsrc_1_4 r0 *1 0,0
Xsky130_fd_sc_hd__lpflow_isobufsrc_1_4 \_0247_ \_0248_ VSS VDD VDD \_0400_
+ sky130_fd_sc_hd__lpflow_isobufsrc_1
* cell instance sky130_fd_sc_hd__lpflow_isobufsrc_1_5 r0 *1 0,0
Xsky130_fd_sc_hd__lpflow_isobufsrc_1_5 \_0276_ \_0370_ VSS VDD VDD \_0371_
+ sky130_fd_sc_hd__lpflow_isobufsrc_1
* cell instance sky130_fd_sc_hd__lpflow_isobufsrc_1_6 r0 *1 0,0
Xsky130_fd_sc_hd__lpflow_isobufsrc_1_6 \_0282_ \_0349_ VSS VDD VDD \_0350_
+ sky130_fd_sc_hd__lpflow_isobufsrc_1
* cell instance sky130_fd_sc_hd__maj3_1_0 r0 *1 0,0
Xsky130_fd_sc_hd__maj3_1_0 mod_r[1] \_0255_ \_0258_ VSS VDD VDD \_0260_
+ sky130_fd_sc_hd__maj3_1
* cell instance sky130_fd_sc_hd__maj3_1_1 r0 *1 0,0
Xsky130_fd_sc_hd__maj3_1_1 mod_r[1] \_0257_ \_0313_ VSS VDD VDD \_0315_
+ sky130_fd_sc_hd__maj3_1
* cell instance sky130_fd_sc_hd__maj3_1_2 r0 *1 0,0
Xsky130_fd_sc_hd__maj3_1_2 mod_r[2] \_0254_ \_0260_ VSS VDD VDD \_0262_
+ sky130_fd_sc_hd__maj3_1
* cell instance sky130_fd_sc_hd__maj3_1_3 r0 *1 0,0
Xsky130_fd_sc_hd__maj3_1_3 mod_r[3] \_0253_ \_0262_ VSS VDD VDD \_0263_
+ sky130_fd_sc_hd__maj3_1
* cell instance sky130_fd_sc_hd__maj3_1_4 r0 *1 0,0
Xsky130_fd_sc_hd__maj3_1_4 mod_r[4] \_0250_ \_0263_ VSS VDD VDD \_0264_
+ sky130_fd_sc_hd__maj3_1
* cell instance sky130_fd_sc_hd__maj3_1_5 r0 *1 0,0
Xsky130_fd_sc_hd__maj3_1_5 mm_p[7] \_0184_ \_0211_ VSS VDD VDD \_0212_
+ sky130_fd_sc_hd__maj3_1
* cell instance sky130_fd_sc_hd__maj3_1_6 r0 *1 0,0
Xsky130_fd_sc_hd__maj3_1_6 mm_p[8] \_0181_ \_0212_ VSS VDD VDD \_0213_
+ sky130_fd_sc_hd__maj3_1
* cell instance sky130_fd_sc_hd__maj3_1_7 r0 *1 0,0
Xsky130_fd_sc_hd__maj3_1_7 mm_p[9] \_0178_ \_0213_ VSS VDD VDD \_0214_
+ sky130_fd_sc_hd__maj3_1
* cell instance sky130_fd_sc_hd__mux2_1_0 r0 *1 0,0
Xsky130_fd_sc_hd__mux2_1_0 mod_in[1] mod_r[1] net6 VSS VDD VDD \_0080_
+ sky130_fd_sc_hd__mux2_1
* cell instance sky130_fd_sc_hd__mux2_1_1 r0 *1 0,0
Xsky130_fd_sc_hd__mux2_1_1 mod_in[0] mod_r[0] net6 VSS VDD VDD \_0081_
+ sky130_fd_sc_hd__mux2_1
* cell instance sky130_fd_sc_hd__mux2_1_2 r0 *1 0,0
Xsky130_fd_sc_hd__mux2_1_2 base_in[1] base_r[1] net6 VSS VDD VDD \_0065_
+ sky130_fd_sc_hd__mux2_1
* cell instance sky130_fd_sc_hd__mux2_1_3 r0 *1 0,0
Xsky130_fd_sc_hd__mux2_1_3 mod_in[4] mod_r[4] net6 VSS VDD VDD \_0077_
+ sky130_fd_sc_hd__mux2_1
* cell instance sky130_fd_sc_hd__mux2_1_4 r0 *1 0,0
Xsky130_fd_sc_hd__mux2_1_4 mod_in[12] mod_r[12] net6 VSS VDD VDD \_0069_
+ sky130_fd_sc_hd__mux2_1
* cell instance sky130_fd_sc_hd__mux2_1_5 r0 *1 0,0
Xsky130_fd_sc_hd__mux2_1_5 base_in[2] base_r[2] net6 VSS VDD VDD \_0064_
+ sky130_fd_sc_hd__mux2_1
* cell instance sky130_fd_sc_hd__mux2_1_6 r0 *1 0,0
Xsky130_fd_sc_hd__mux2_1_6 mod_in[6] mod_r[6] net6 VSS VDD VDD \_0075_
+ sky130_fd_sc_hd__mux2_1
* cell instance sky130_fd_sc_hd__mux2_1_7 r0 *1 0,0
Xsky130_fd_sc_hd__mux2_1_7 mod_in[3] mod_r[3] net6 VSS VDD VDD \_0078_
+ sky130_fd_sc_hd__mux2_1
* cell instance sky130_fd_sc_hd__mux2_1_8 r0 *1 0,0
Xsky130_fd_sc_hd__mux2_1_8 base_in[4] base_r[4] net6 VSS VDD VDD \_0062_
+ sky130_fd_sc_hd__mux2_1
* cell instance sky130_fd_sc_hd__mux2_1_9 r0 *1 0,0
Xsky130_fd_sc_hd__mux2_1_9 mod_in[5] mod_r[5] net6 VSS VDD VDD \_0076_
+ sky130_fd_sc_hd__mux2_1
* cell instance sky130_fd_sc_hd__mux2_1_10 r0 *1 0,0
Xsky130_fd_sc_hd__mux2_1_10 base_in[3] base_r[3] net6 VSS VDD VDD \_0063_
+ sky130_fd_sc_hd__mux2_1
* cell instance sky130_fd_sc_hd__mux2_1_11 r0 *1 0,0
Xsky130_fd_sc_hd__mux2_1_11 base_in[5] base_r[5] net6 VSS VDD VDD \_0061_
+ sky130_fd_sc_hd__mux2_1
* cell instance sky130_fd_sc_hd__mux2_1_12 r0 *1 0,0
Xsky130_fd_sc_hd__mux2_1_12 base_in[10] base_r[10] net6 VSS VDD VDD \_0056_
+ sky130_fd_sc_hd__mux2_1
* cell instance sky130_fd_sc_hd__mux2_1_13 r0 *1 0,0
Xsky130_fd_sc_hd__mux2_1_13 base_in[7] base_r[7] net6 VSS VDD VDD \_0059_
+ sky130_fd_sc_hd__mux2_1
* cell instance sky130_fd_sc_hd__mux2_1_14 r0 *1 0,0
Xsky130_fd_sc_hd__mux2_1_14 mod_in[9] mod_r[9] net6 VSS VDD VDD \_0072_
+ sky130_fd_sc_hd__mux2_1
* cell instance sky130_fd_sc_hd__mux2_1_15 r0 *1 0,0
Xsky130_fd_sc_hd__mux2_1_15 mod_in[7] mod_r[7] net6 VSS VDD VDD \_0074_
+ sky130_fd_sc_hd__mux2_1
* cell instance sky130_fd_sc_hd__mux2_1_16 r0 *1 0,0
Xsky130_fd_sc_hd__mux2_1_16 base_in[9] base_r[9] net6 VSS VDD VDD \_0057_
+ sky130_fd_sc_hd__mux2_1
* cell instance sky130_fd_sc_hd__mux2_1_17 r0 *1 0,0
Xsky130_fd_sc_hd__mux2_1_17 mod_in[8] mod_r[8] net6 VSS VDD VDD \_0073_
+ sky130_fd_sc_hd__mux2_1
* cell instance sky130_fd_sc_hd__mux2_1_18 r0 *1 0,0
Xsky130_fd_sc_hd__mux2_1_18 base_in[6] base_r[6] net6 VSS VDD VDD \_0060_
+ sky130_fd_sc_hd__mux2_1
* cell instance sky130_fd_sc_hd__mux2_1_19 r0 *1 0,0
Xsky130_fd_sc_hd__mux2_1_19 mod_in[2] mod_r[2] net6 VSS VDD VDD \_0079_
+ sky130_fd_sc_hd__mux2_1
* cell instance sky130_fd_sc_hd__mux2_1_20 r0 *1 0,0
Xsky130_fd_sc_hd__mux2_1_20 base_in[8] base_r[8] net6 VSS VDD VDD \_0058_
+ sky130_fd_sc_hd__mux2_1
* cell instance sky130_fd_sc_hd__mux2_1_21 r0 *1 0,0
Xsky130_fd_sc_hd__mux2_1_21 base_in[0] base_r[0] net6 VSS VDD VDD \_0066_
+ sky130_fd_sc_hd__mux2_1
* cell instance sky130_fd_sc_hd__mux2_1_22 r0 *1 0,0
Xsky130_fd_sc_hd__mux2_1_22 base_in[12] base_r[12] net6 VSS VDD VDD \_0054_
+ sky130_fd_sc_hd__mux2_1
* cell instance sky130_fd_sc_hd__mux2_1_23 r0 *1 0,0
Xsky130_fd_sc_hd__mux2_1_23 base_in[11] base_r[11] net6 VSS VDD VDD \_0055_
+ sky130_fd_sc_hd__mux2_1
* cell instance sky130_fd_sc_hd__mux2_1_24 r0 *1 0,0
Xsky130_fd_sc_hd__mux2_1_24 mod_in[10] mod_r[10] net6 VSS VDD VDD \_0071_
+ sky130_fd_sc_hd__mux2_1
* cell instance sky130_fd_sc_hd__mux2_1_25 r0 *1 0,0
Xsky130_fd_sc_hd__mux2_1_25 base_in[13] base_r[13] net6 VSS VDD VDD \_0053_
+ sky130_fd_sc_hd__mux2_1
* cell instance sky130_fd_sc_hd__mux2_1_26 r0 *1 0,0
Xsky130_fd_sc_hd__mux2_1_26 base_in[14] base_r[14] net6 VSS VDD VDD \_0052_
+ sky130_fd_sc_hd__mux2_1
* cell instance sky130_fd_sc_hd__mux2_1_27 r0 *1 0,0
Xsky130_fd_sc_hd__mux2_1_27 mod_in[11] mod_r[11] net6 VSS VDD VDD \_0070_
+ sky130_fd_sc_hd__mux2_1
* cell instance sky130_fd_sc_hd__mux2_1_28 r0 *1 0,0
Xsky130_fd_sc_hd__mux2_1_28 base_in[15] base_r[15] net6 VSS VDD VDD \_0100_
+ sky130_fd_sc_hd__mux2_1
* cell instance sky130_fd_sc_hd__mux2_1_29 r0 *1 0,0
Xsky130_fd_sc_hd__mux2_1_29 mod_in[14] mod_r[14] net6 VSS VDD VDD \_0067_
+ sky130_fd_sc_hd__mux2_1
* cell instance sky130_fd_sc_hd__mux2_1_30 r0 *1 0,0
Xsky130_fd_sc_hd__mux2_1_30 mod_in[13] mod_r[13] net6 VSS VDD VDD \_0068_
+ sky130_fd_sc_hd__mux2_1
* cell instance sky130_fd_sc_hd__mux2_1_31 r0 *1 0,0
Xsky130_fd_sc_hd__mux2_1_31 mod_in[15] mod_r[15] net6 VSS VDD VDD \_0089_
+ sky130_fd_sc_hd__mux2_1
* cell instance sky130_fd_sc_hd__mux2i_1_0 r0 *1 0,0
Xsky130_fd_sc_hd__mux2i_1_0 exp_in[15] exp_r[14] state[1] VSS VDD VDD \_0543_
+ sky130_fd_sc_hd__mux2i_1
* cell instance sky130_fd_sc_hd__mux2i_1_1 r0 *1 0,0
Xsky130_fd_sc_hd__mux2i_1_1 exp_in[1] exp_r[0] state[1] VSS VDD VDD \_0527_
+ sky130_fd_sc_hd__mux2i_1
* cell instance sky130_fd_sc_hd__mux2i_1_2 r0 *1 0,0
Xsky130_fd_sc_hd__mux2i_1_2 exp_in[2] exp_r[1] state[1] VSS VDD VDD \_0525_
+ sky130_fd_sc_hd__mux2i_1
* cell instance sky130_fd_sc_hd__mux2i_1_3 r0 *1 0,0
Xsky130_fd_sc_hd__mux2i_1_3 \_0257_ \_0429_ \_0344_ VSS VDD VDD \_0430_
+ sky130_fd_sc_hd__mux2i_1
* cell instance sky130_fd_sc_hd__mux2i_1_4 r0 *1 0,0
Xsky130_fd_sc_hd__mux2i_1_4 exp_in[14] exp_r[13] state[1] VSS VDD VDD \_0443_
+ sky130_fd_sc_hd__mux2i_1
* cell instance sky130_fd_sc_hd__mux2i_1_5 r0 *1 0,0
Xsky130_fd_sc_hd__mux2i_1_5 exp_in[3] exp_r[2] state[1] VSS VDD VDD \_0517_
+ sky130_fd_sc_hd__mux2i_1
* cell instance sky130_fd_sc_hd__mux2i_1_6 r0 *1 0,0
Xsky130_fd_sc_hd__mux2i_1_6 exp_in[13] exp_r[12] state[1] VSS VDD VDD \_0445_
+ sky130_fd_sc_hd__mux2i_1
* cell instance sky130_fd_sc_hd__mux2i_1_7 r0 *1 0,0
Xsky130_fd_sc_hd__mux2i_1_7 exp_in[4] exp_r[3] state[1] VSS VDD VDD \_0515_
+ sky130_fd_sc_hd__mux2i_1
* cell instance sky130_fd_sc_hd__mux2i_1_8 r0 *1 0,0
Xsky130_fd_sc_hd__mux2i_1_8 exp_in[12] exp_r[11] state[1] VSS VDD VDD \_0447_
+ sky130_fd_sc_hd__mux2i_1
* cell instance sky130_fd_sc_hd__mux2i_1_9 r0 *1 0,0
Xsky130_fd_sc_hd__mux2i_1_9 exp_in[11] exp_r[10] state[1] VSS VDD VDD \_0449_
+ sky130_fd_sc_hd__mux2i_1
* cell instance sky130_fd_sc_hd__mux2i_1_10 r0 *1 0,0
Xsky130_fd_sc_hd__mux2i_1_10 exp_in[5] exp_r[4] state[1] VSS VDD VDD \_0513_
+ sky130_fd_sc_hd__mux2i_1
* cell instance sky130_fd_sc_hd__mux2i_1_11 r0 *1 0,0
Xsky130_fd_sc_hd__mux2i_1_11 \_0246_ \_0397_ \_0344_ VSS VDD VDD \_0398_
+ sky130_fd_sc_hd__mux2i_1
* cell instance sky130_fd_sc_hd__mux2i_1_12 r0 *1 0,0
Xsky130_fd_sc_hd__mux2i_1_12 exp_in[9] exp_r[8] state[1] VSS VDD VDD \_0501_
+ sky130_fd_sc_hd__mux2i_1
* cell instance sky130_fd_sc_hd__mux2i_1_13 r0 *1 0,0
Xsky130_fd_sc_hd__mux2i_1_13 exp_in[6] exp_r[5] state[1] VSS VDD VDD \_0507_
+ sky130_fd_sc_hd__mux2i_1
* cell instance sky130_fd_sc_hd__mux2i_1_14 r0 *1 0,0
Xsky130_fd_sc_hd__mux2i_1_14 exp_in[10] exp_r[9] state[1] VSS VDD VDD \_0499_
+ sky130_fd_sc_hd__mux2i_1
* cell instance sky130_fd_sc_hd__mux2i_1_15 r0 *1 0,0
Xsky130_fd_sc_hd__mux2i_1_15 exp_in[7] exp_r[6] state[1] VSS VDD VDD \_0505_
+ sky130_fd_sc_hd__mux2i_1
* cell instance sky130_fd_sc_hd__mux2i_1_16 r0 *1 0,0
Xsky130_fd_sc_hd__mux2i_1_16 exp_in[8] exp_r[7] state[1] VSS VDD VDD \_0503_
+ sky130_fd_sc_hd__mux2i_1
* cell instance sky130_fd_sc_hd__mux2i_1_17 r0 *1 0,0
Xsky130_fd_sc_hd__mux2i_1_17 \_0227_ \_0353_ \_0344_ VSS VDD VDD \_0354_
+ sky130_fd_sc_hd__mux2i_1
* cell instance sky130_fd_sc_hd__mux2i_1_18 r0 *1 0,0
Xsky130_fd_sc_hd__mux2i_1_18 \_0225_ \_0346_ \_0344_ VSS VDD VDD \_0347_
+ sky130_fd_sc_hd__mux2i_1
* cell instance sky130_fd_sc_hd__nand2_1_0 r0 *1 0,0
Xsky130_fd_sc_hd__nand2_1_0 \_0157_ \_0160_ VSS VDD VDD \_0015_
+ sky130_fd_sc_hd__nand2_1
* cell instance sky130_fd_sc_hd__nand2_1_1 r0 *1 0,0
Xsky130_fd_sc_hd__nand2_1_1 \_0156_ \_0158_ VSS VDD VDD \_0014_
+ sky130_fd_sc_hd__nand2_1
* cell instance sky130_fd_sc_hd__nand2_1_2 r0 *1 0,0
Xsky130_fd_sc_hd__nand2_1_2 \_0538_ \_0539_ VSS VDD VDD \_0119_
+ sky130_fd_sc_hd__nand2_1
* cell instance sky130_fd_sc_hd__nand2_1_3 r0 *1 0,0
Xsky130_fd_sc_hd__nand2_1_3 \_0146_ \_0535_ VSS VDD VDD \_0116_
+ sky130_fd_sc_hd__nand2_1
* cell instance sky130_fd_sc_hd__nand2_1_4 r0 *1 0,0
Xsky130_fd_sc_hd__nand2_1_4 \_0540_ \_0542_ VSS VDD VDD \_0120_
+ sky130_fd_sc_hd__nand2_1
* cell instance sky130_fd_sc_hd__nand2_1_5 r0 *1 0,0
Xsky130_fd_sc_hd__nand2_1_5 state[1] \_0530_ VSS VDD VDD \_0539_
+ sky130_fd_sc_hd__nand2_1
* cell instance sky130_fd_sc_hd__nand2_1_6 r0 *1 0,0
Xsky130_fd_sc_hd__nand2_1_6 state[2] \_0155_ VSS VDD VDD \_0157_
+ sky130_fd_sc_hd__nand2_1
* cell instance sky130_fd_sc_hd__nand2_1_7 r0 *1 0,0
Xsky130_fd_sc_hd__nand2_1_7 outer[0] \_0509_ VSS VDD VDD \_0538_
+ sky130_fd_sc_hd__nand2_1
* cell instance sky130_fd_sc_hd__nand2_1_8 r0 *1 0,0
Xsky130_fd_sc_hd__nand2_1_8 \_0139_ \_0146_ VSS VDD VDD \_0159_
+ sky130_fd_sc_hd__nand2_1
* cell instance sky130_fd_sc_hd__nand2_1_9 r0 *1 0,0
Xsky130_fd_sc_hd__nand2_1_9 state[1] \_0134_ VSS VDD VDD \_0141_
+ sky130_fd_sc_hd__nand2_1
* cell instance sky130_fd_sc_hd__nand2_1_10 r0 *1 0,0
Xsky130_fd_sc_hd__nand2_1_10 state[1] \_0135_ VSS VDD VDD \_0136_
+ sky130_fd_sc_hd__nand2_1
* cell instance sky130_fd_sc_hd__nand2_1_11 r0 *1 0,0
Xsky130_fd_sc_hd__nand2_1_11 state[2] \_0138_ VSS VDD VDD \_0139_
+ sky130_fd_sc_hd__nand2_1
* cell instance sky130_fd_sc_hd__nand2_1_12 r0 *1 0,0
Xsky130_fd_sc_hd__nand2_1_12 exp_r[14] \_0442_ VSS VDD VDD \_0444_
+ sky130_fd_sc_hd__nand2_1
* cell instance sky130_fd_sc_hd__nand2_1_13 r0 *1 0,0
Xsky130_fd_sc_hd__nand2_1_13 exp_r[15] \_0442_ VSS VDD VDD \_0544_
+ sky130_fd_sc_hd__nand2_1
* cell instance sky130_fd_sc_hd__nand2_1_14 r0 *1 0,0
Xsky130_fd_sc_hd__nand2_1_14 mm_a[0] \_0140_ VSS VDD VDD \_0154_
+ sky130_fd_sc_hd__nand2_1
* cell instance sky130_fd_sc_hd__nand2_1_15 r0 *1 0,0
Xsky130_fd_sc_hd__nand2_1_15 \_0440_ \_0442_ VSS VDD VDD \_0511_
+ sky130_fd_sc_hd__nand2_1
* cell instance sky130_fd_sc_hd__nand2_1_16 r0 *1 0,0
Xsky130_fd_sc_hd__nand2_1_16 state[5] \_0144_ VSS VDD VDD \_0440_
+ sky130_fd_sc_hd__nand2_1
* cell instance sky130_fd_sc_hd__nand2_1_17 r0 *1 0,0
Xsky130_fd_sc_hd__nand2_1_17 mm_p[1] \_0140_ VSS VDD VDD \_0428_
+ sky130_fd_sc_hd__nand2_1
* cell instance sky130_fd_sc_hd__nand2_1_18 r0 *1 0,0
Xsky130_fd_sc_hd__nand2_1_18 exp_r[1] \_0442_ VSS VDD VDD \_0528_
+ sky130_fd_sc_hd__nand2_1
* cell instance sky130_fd_sc_hd__nand2_1_19 r0 *1 0,0
Xsky130_fd_sc_hd__nand2_1_19 state[0] start VSS VDD VDD \_0143_
+ sky130_fd_sc_hd__nand2_1
* cell instance sky130_fd_sc_hd__nand2_1_20 r0 *1 0,0
Xsky130_fd_sc_hd__nand2_1_20 mm_p[2] \_0140_ VSS VDD VDD \_0422_
+ sky130_fd_sc_hd__nand2_1
* cell instance sky130_fd_sc_hd__nand2_1_21 r0 *1 0,0
Xsky130_fd_sc_hd__nand2_1_21 result[1] \_0131_ VSS VDD VDD \_0493_
+ sky130_fd_sc_hd__nand2_1
* cell instance sky130_fd_sc_hd__nand2_1_22 r0 *1 0,0
Xsky130_fd_sc_hd__nand2_1_22 exp_r[2] \_0442_ VSS VDD VDD \_0526_
+ sky130_fd_sc_hd__nand2_1
* cell instance sky130_fd_sc_hd__nand2_1_23 r0 *1 0,0
Xsky130_fd_sc_hd__nand2_1_23 exp_r[13] \_0442_ VSS VDD VDD \_0446_
+ sky130_fd_sc_hd__nand2_1
* cell instance sky130_fd_sc_hd__nand2_1_24 r0 *1 0,0
Xsky130_fd_sc_hd__nand2_1_24 mm_p[0] \_0140_ VSS VDD VDD \_0434_
+ sky130_fd_sc_hd__nand2_1
* cell instance sky130_fd_sc_hd__nand2_1_25 r0 *1 0,0
Xsky130_fd_sc_hd__nand2_1_25 mm_phase base_r[1] VSS VDD VDD \_0494_
+ sky130_fd_sc_hd__nand2_1
* cell instance sky130_fd_sc_hd__nand2_1_26 r0 *1 0,0
Xsky130_fd_sc_hd__nand2_1_26 mod_r[0] \_0344_ VSS VDD VDD \_0435_
+ sky130_fd_sc_hd__nand2_1
* cell instance sky130_fd_sc_hd__nand2_1_27 r0 *1 0,0
Xsky130_fd_sc_hd__nand2_1_27 \_0289_ \_0419_ VSS VDD VDD \_0420_
+ sky130_fd_sc_hd__nand2_1
* cell instance sky130_fd_sc_hd__nand2_1_28 r0 *1 0,0
Xsky130_fd_sc_hd__nand2_1_28 \_0344_ \_0417_ VSS VDD VDD \_0418_
+ sky130_fd_sc_hd__nand2_1
* cell instance sky130_fd_sc_hd__nand2_1_29 r0 *1 0,0
Xsky130_fd_sc_hd__nand2_1_29 \_0200_ \_0256_ VSS VDD VDD \_0257_
+ sky130_fd_sc_hd__nand2_1
* cell instance sky130_fd_sc_hd__nand2_1_30 r0 *1 0,0
Xsky130_fd_sc_hd__nand2_1_30 mm_phase base_r[2] VSS VDD VDD \_0491_
+ sky130_fd_sc_hd__nand2_1
* cell instance sky130_fd_sc_hd__nand2_1_31 r0 *1 0,0
Xsky130_fd_sc_hd__nand2_1_31 result[2] \_0131_ VSS VDD VDD \_0490_
+ sky130_fd_sc_hd__nand2_1
* cell instance sky130_fd_sc_hd__nand2_1_32 r0 *1 0,0
Xsky130_fd_sc_hd__nand2_1_32 exp_r[12] \_0442_ VSS VDD VDD \_0448_
+ sky130_fd_sc_hd__nand2_1
* cell instance sky130_fd_sc_hd__nand2_1_33 r0 *1 0,0
Xsky130_fd_sc_hd__nand2_1_33 mm_a[15] mm_b[0] VSS VDD VDD \_0312_
+ sky130_fd_sc_hd__nand2_1
* cell instance sky130_fd_sc_hd__nand2_1_34 r0 *1 0,0
Xsky130_fd_sc_hd__nand2_1_34 mod_r[3] \_0254_ VSS VDD VDD \_0310_
+ sky130_fd_sc_hd__nand2_1
* cell instance sky130_fd_sc_hd__nand2_1_35 r0 *1 0,0
Xsky130_fd_sc_hd__nand2_1_35 exp_r[3] \_0442_ VSS VDD VDD \_0518_
+ sky130_fd_sc_hd__nand2_1
* cell instance sky130_fd_sc_hd__nand2_1_36 r0 *1 0,0
Xsky130_fd_sc_hd__nand2_1_36 mm_a[15] mm_b[2] VSS VDD VDD \_0198_
+ sky130_fd_sc_hd__nand2_1
* cell instance sky130_fd_sc_hd__nand2_1_37 r0 *1 0,0
Xsky130_fd_sc_hd__nand2_1_37 result[3] \_0131_ VSS VDD VDD \_0487_
+ sky130_fd_sc_hd__nand2_1
* cell instance sky130_fd_sc_hd__nand2_1_38 r0 *1 0,0
Xsky130_fd_sc_hd__nand2_1_38 \_0344_ \_0404_ VSS VDD VDD \_0405_
+ sky130_fd_sc_hd__nand2_1
* cell instance sky130_fd_sc_hd__nand2_1_39 r0 *1 0,0
Xsky130_fd_sc_hd__nand2_1_39 \_0289_ \_0406_ VSS VDD VDD \_0407_
+ sky130_fd_sc_hd__nand2_1
* cell instance sky130_fd_sc_hd__nand2_1_40 r0 *1 0,0
Xsky130_fd_sc_hd__nand2_1_40 exp_r[11] \_0442_ VSS VDD VDD \_0450_
+ sky130_fd_sc_hd__nand2_1
* cell instance sky130_fd_sc_hd__nand2_1_41 r0 *1 0,0
Xsky130_fd_sc_hd__nand2_1_41 mm_phase base_r[4] VSS VDD VDD \_0485_
+ sky130_fd_sc_hd__nand2_1
* cell instance sky130_fd_sc_hd__nand2_1_42 r0 *1 0,0
Xsky130_fd_sc_hd__nand2_1_42 result[4] \_0131_ VSS VDD VDD \_0484_
+ sky130_fd_sc_hd__nand2_1
* cell instance sky130_fd_sc_hd__nand2_1_43 r0 *1 0,0
Xsky130_fd_sc_hd__nand2_1_43 exp_r[4] \_0442_ VSS VDD VDD \_0516_
+ sky130_fd_sc_hd__nand2_1
* cell instance sky130_fd_sc_hd__nand2_1_44 r0 *1 0,0
Xsky130_fd_sc_hd__nand2_1_44 mm_phase base_r[3] VSS VDD VDD \_0488_
+ sky130_fd_sc_hd__nand2_1
* cell instance sky130_fd_sc_hd__nand2_1_45 r0 *1 0,0
Xsky130_fd_sc_hd__nand2_1_45 result[5] \_0131_ VSS VDD VDD \_0481_
+ sky130_fd_sc_hd__nand2_1
* cell instance sky130_fd_sc_hd__nand2_1_46 r0 *1 0,0
Xsky130_fd_sc_hd__nand2_1_46 mm_p[4] \_0140_ VSS VDD VDD \_0409_
+ sky130_fd_sc_hd__nand2_1
* cell instance sky130_fd_sc_hd__nand2_1_47 r0 *1 0,0
Xsky130_fd_sc_hd__nand2_1_47 mm_phase base_r[5] VSS VDD VDD \_0482_
+ sky130_fd_sc_hd__nand2_1
* cell instance sky130_fd_sc_hd__nand2_1_48 r0 *1 0,0
Xsky130_fd_sc_hd__nand2_1_48 exp_r[10] \_0442_ VSS VDD VDD \_0500_
+ sky130_fd_sc_hd__nand2_1
* cell instance sky130_fd_sc_hd__nand2_1_49 r0 *1 0,0
Xsky130_fd_sc_hd__nand2_1_49 result[6] \_0131_ VSS VDD VDD \_0478_
+ sky130_fd_sc_hd__nand2_1
* cell instance sky130_fd_sc_hd__nand2_1_50 r0 *1 0,0
Xsky130_fd_sc_hd__nand2_1_50 net4 \_0398_ VSS VDD VDD \_0399_
+ sky130_fd_sc_hd__nand2_1
* cell instance sky130_fd_sc_hd__nand2_1_51 r0 *1 0,0
Xsky130_fd_sc_hd__nand2_1_51 \_0289_ \_0401_ VSS VDD VDD \_0402_
+ sky130_fd_sc_hd__nand2_1
* cell instance sky130_fd_sc_hd__nand2_1_52 r0 *1 0,0
Xsky130_fd_sc_hd__nand2_1_52 exp_r[5] \_0442_ VSS VDD VDD \_0514_
+ sky130_fd_sc_hd__nand2_1
* cell instance sky130_fd_sc_hd__nand2_1_53 r0 *1 0,0
Xsky130_fd_sc_hd__nand2_1_53 \_0289_ \_0394_ VSS VDD VDD \_0396_
+ sky130_fd_sc_hd__nand2_1
* cell instance sky130_fd_sc_hd__nand2_1_54 r0 *1 0,0
Xsky130_fd_sc_hd__nand2_1_54 mm_phase base_r[7] VSS VDD VDD \_0476_
+ sky130_fd_sc_hd__nand2_1
* cell instance sky130_fd_sc_hd__nand2_1_55 r0 *1 0,0
Xsky130_fd_sc_hd__nand2_1_55 \_0191_ \_0209_ VSS VDD VDD \_0210_
+ sky130_fd_sc_hd__nand2_1
* cell instance sky130_fd_sc_hd__nand2_1_56 r0 *1 0,0
Xsky130_fd_sc_hd__nand2_1_56 exp_r[9] \_0442_ VSS VDD VDD \_0502_
+ sky130_fd_sc_hd__nand2_1
* cell instance sky130_fd_sc_hd__nand2_1_57 r0 *1 0,0
Xsky130_fd_sc_hd__nand2_1_57 result[7] \_0131_ VSS VDD VDD \_0475_
+ sky130_fd_sc_hd__nand2_1
* cell instance sky130_fd_sc_hd__nand2_1_58 r0 *1 0,0
Xsky130_fd_sc_hd__nand2_1_58 exp_r[6] \_0442_ VSS VDD VDD \_0508_
+ sky130_fd_sc_hd__nand2_1
* cell instance sky130_fd_sc_hd__nand2_1_59 r0 *1 0,0
Xsky130_fd_sc_hd__nand2_1_59 \_0326_ \_0327_ VSS VDD VDD \_0387_
+ sky130_fd_sc_hd__nand2_1
* cell instance sky130_fd_sc_hd__nand2_1_60 r0 *1 0,0
Xsky130_fd_sc_hd__nand2_1_60 mm_phase base_r[9] VSS VDD VDD \_0470_
+ sky130_fd_sc_hd__nand2_1
* cell instance sky130_fd_sc_hd__nand2_1_61 r0 *1 0,0
Xsky130_fd_sc_hd__nand2_1_61 result[9] \_0131_ VSS VDD VDD \_0469_
+ sky130_fd_sc_hd__nand2_1
* cell instance sky130_fd_sc_hd__nand2_1_62 r0 *1 0,0
Xsky130_fd_sc_hd__nand2_1_62 mm_phase base_r[6] VSS VDD VDD \_0479_
+ sky130_fd_sc_hd__nand2_1
* cell instance sky130_fd_sc_hd__nand2_1_63 r0 *1 0,0
Xsky130_fd_sc_hd__nand2_1_63 mm_p[8] \_0140_ VSS VDD VDD \_0386_
+ sky130_fd_sc_hd__nand2_1
* cell instance sky130_fd_sc_hd__nand2_1_64 r0 *1 0,0
Xsky130_fd_sc_hd__nand2_1_64 mm_a[15] mm_b[9] VSS VDD VDD \_0180_
+ sky130_fd_sc_hd__nand2_1
* cell instance sky130_fd_sc_hd__nand2_1_65 r0 *1 0,0
Xsky130_fd_sc_hd__nand2_1_65 mod_r[9] \_0237_ VSS VDD VDD \_0299_
+ sky130_fd_sc_hd__nand2_1
* cell instance sky130_fd_sc_hd__nand2_1_66 r0 *1 0,0
Xsky130_fd_sc_hd__nand2_1_66 mm_phase base_r[10] VSS VDD VDD \_0464_
+ sky130_fd_sc_hd__nand2_1
* cell instance sky130_fd_sc_hd__nand2_1_67 r0 *1 0,0
Xsky130_fd_sc_hd__nand2_1_67 \_0289_ \_0383_ VSS VDD VDD \_0384_
+ sky130_fd_sc_hd__nand2_1
* cell instance sky130_fd_sc_hd__nand2_1_68 r0 *1 0,0
Xsky130_fd_sc_hd__nand2_1_68 exp_r[7] \_0442_ VSS VDD VDD \_0506_
+ sky130_fd_sc_hd__nand2_1
* cell instance sky130_fd_sc_hd__nand2_1_69 r0 *1 0,0
Xsky130_fd_sc_hd__nand2_1_69 \_0329_ \_0378_ VSS VDD VDD \_0380_
+ sky130_fd_sc_hd__nand2_1
* cell instance sky130_fd_sc_hd__nand2_1_70 r0 *1 0,0
Xsky130_fd_sc_hd__nand2_1_70 \_0297_ \_0299_ VSS VDD VDD \_0378_
+ sky130_fd_sc_hd__nand2_1
* cell instance sky130_fd_sc_hd__nand2_1_71 r0 *1 0,0
Xsky130_fd_sc_hd__nand2_1_71 exp_r[8] \_0442_ VSS VDD VDD \_0504_
+ sky130_fd_sc_hd__nand2_1
* cell instance sky130_fd_sc_hd__nand2_1_72 r0 *1 0,0
Xsky130_fd_sc_hd__nand2_1_72 result[10] \_0131_ VSS VDD VDD \_0463_
+ sky130_fd_sc_hd__nand2_1
* cell instance sky130_fd_sc_hd__nand2_1_73 r0 *1 0,0
Xsky130_fd_sc_hd__nand2_1_73 mm_phase base_r[8] VSS VDD VDD \_0473_
+ sky130_fd_sc_hd__nand2_1
* cell instance sky130_fd_sc_hd__nand2_1_74 r0 *1 0,0
Xsky130_fd_sc_hd__nand2_1_74 result[8] \_0131_ VSS VDD VDD \_0472_
+ sky130_fd_sc_hd__nand2_1
* cell instance sky130_fd_sc_hd__nand2_1_75 r0 *1 0,0
Xsky130_fd_sc_hd__nand2_1_75 mm_a[15] mm_b[8] VSS VDD VDD \_0183_
+ sky130_fd_sc_hd__nand2_1
* cell instance sky130_fd_sc_hd__nand2_1_76 r0 *1 0,0
Xsky130_fd_sc_hd__nand2_1_76 mod_r[9] \_0234_ VSS VDD VDD \_0273_
+ sky130_fd_sc_hd__nand2_1
* cell instance sky130_fd_sc_hd__nand2_1_77 r0 *1 0,0
Xsky130_fd_sc_hd__nand2_1_77 \_0289_ \_0376_ VSS VDD VDD \_0377_
+ sky130_fd_sc_hd__nand2_1
* cell instance sky130_fd_sc_hd__nand2_1_78 r0 *1 0,0
Xsky130_fd_sc_hd__nand2_1_78 \_0344_ \_0373_ VSS VDD VDD \_0374_
+ sky130_fd_sc_hd__nand2_1
* cell instance sky130_fd_sc_hd__nand2_1_79 r0 *1 0,0
Xsky130_fd_sc_hd__nand2_1_79 mm_a[15] mm_b[10] VSS VDD VDD \_0177_
+ sky130_fd_sc_hd__nand2_1
* cell instance sky130_fd_sc_hd__nand2_1_80 r0 *1 0,0
Xsky130_fd_sc_hd__nand2_1_80 mm_phase base_r[12] VSS VDD VDD \_0458_
+ sky130_fd_sc_hd__nand2_1
* cell instance sky130_fd_sc_hd__nand2_1_81 r0 *1 0,0
Xsky130_fd_sc_hd__nand2_1_81 result[12] \_0131_ VSS VDD VDD \_0457_
+ sky130_fd_sc_hd__nand2_1
* cell instance sky130_fd_sc_hd__nand2_1_82 r0 *1 0,0
Xsky130_fd_sc_hd__nand2_1_82 mm_phase base_r[11] VSS VDD VDD \_0461_
+ sky130_fd_sc_hd__nand2_1
* cell instance sky130_fd_sc_hd__nand2_1_83 r0 *1 0,0
Xsky130_fd_sc_hd__nand2_1_83 result[11] \_0131_ VSS VDD VDD \_0460_
+ sky130_fd_sc_hd__nand2_1
* cell instance sky130_fd_sc_hd__nand2_1_84 r0 *1 0,0
Xsky130_fd_sc_hd__nand2_1_84 mod_r[10] \_0232_ VSS VDD VDD \_0275_
+ sky130_fd_sc_hd__nand2_1
* cell instance sky130_fd_sc_hd__nand2_1_85 r0 *1 0,0
Xsky130_fd_sc_hd__nand2_1_85 mm_p[11] \_0140_ VSS VDD VDD \_0365_
+ sky130_fd_sc_hd__nand2_1
* cell instance sky130_fd_sc_hd__nand2_1_86 r0 *1 0,0
Xsky130_fd_sc_hd__nand2_1_86 mm_phase base_r[13] VSS VDD VDD \_0455_
+ sky130_fd_sc_hd__nand2_1
* cell instance sky130_fd_sc_hd__nand2_1_87 r0 *1 0,0
Xsky130_fd_sc_hd__nand2_1_87 result[13] \_0131_ VSS VDD VDD \_0454_
+ sky130_fd_sc_hd__nand2_1
* cell instance sky130_fd_sc_hd__nand2_1_88 r0 *1 0,0
Xsky130_fd_sc_hd__nand2_1_88 \_0131_ result[15] VSS VDD VDD \_0466_
+ sky130_fd_sc_hd__nand2_1
* cell instance sky130_fd_sc_hd__nand2_1_89 r0 *1 0,0
Xsky130_fd_sc_hd__nand2_1_89 result[14] \_0131_ VSS VDD VDD \_0451_
+ sky130_fd_sc_hd__nand2_1
* cell instance sky130_fd_sc_hd__nand2_1_90 r0 *1 0,0
Xsky130_fd_sc_hd__nand2_1_90 base_r[14] mm_phase VSS VDD VDD \_0452_
+ sky130_fd_sc_hd__nand2_1
* cell instance sky130_fd_sc_hd__nand2_1_91 r0 *1 0,0
Xsky130_fd_sc_hd__nand2_1_91 mm_phase base_r[15] VSS VDD VDD \_0467_
+ sky130_fd_sc_hd__nand2_1
* cell instance sky130_fd_sc_hd__nand2_1_92 r0 *1 0,0
Xsky130_fd_sc_hd__nand2_1_92 \_0169_ \_0170_ VSS VDD VDD \_0171_
+ sky130_fd_sc_hd__nand2_1
* cell instance sky130_fd_sc_hd__nand2_1_93 r0 *1 0,0
Xsky130_fd_sc_hd__nand2_1_93 \_0289_ \_0363_ VSS VDD VDD \_0364_
+ sky130_fd_sc_hd__nand2_1
* cell instance sky130_fd_sc_hd__nand2_1_94 r0 *1 0,0
Xsky130_fd_sc_hd__nand2_1_94 \_0164_ \_0165_ VSS VDD VDD \_0166_
+ sky130_fd_sc_hd__nand2_1
* cell instance sky130_fd_sc_hd__nand2_1_95 r0 *1 0,0
Xsky130_fd_sc_hd__nand2_1_95 mm_p[15] \_0220_ VSS VDD VDD \_0287_
+ sky130_fd_sc_hd__nand2_1
* cell instance sky130_fd_sc_hd__nand2_1_96 r0 *1 0,0
Xsky130_fd_sc_hd__nand2_1_96 mm_p[13] \_0140_ VSS VDD VDD \_0352_
+ sky130_fd_sc_hd__nand2_1
* cell instance sky130_fd_sc_hd__nand2_1_97 r0 *1 0,0
Xsky130_fd_sc_hd__nand2_1_97 mod_r[15] \_0221_ VSS VDD VDD \_0223_
+ sky130_fd_sc_hd__nand2_1
* cell instance sky130_fd_sc_hd__nand2_1_98 r0 *1 0,0
Xsky130_fd_sc_hd__nand2_1_98 net4 \_0520_ VSS VDD VDD \_0521_
+ sky130_fd_sc_hd__nand2_1
* cell instance sky130_fd_sc_hd__nand2_1_99 r0 *1 0,0
Xsky130_fd_sc_hd__nand2_1_99 \_0289_ \_0523_ VSS VDD VDD \_0524_
+ sky130_fd_sc_hd__nand2_1
* cell instance sky130_fd_sc_hd__nand2_1_100 r0 *1 0,0
Xsky130_fd_sc_hd__nand2_1_100 mm_p[14] \_0140_ VSS VDD VDD \_0163_
+ sky130_fd_sc_hd__nand2_1
* cell instance sky130_fd_sc_hd__nand2b_1_0 r0 *1 0,0
Xsky130_fd_sc_hd__nand2b_1_0 j[1] j[0] VSS VDD VDD \_0137_
+ sky130_fd_sc_hd__nand2b_1
* cell instance sky130_fd_sc_hd__nand2b_1_1 r0 *1 0,0
Xsky130_fd_sc_hd__nand2b_1_1 state[3] \_0139_ VSS VDD VDD \_0004_
+ sky130_fd_sc_hd__nand2b_1
* cell instance sky130_fd_sc_hd__nand2b_1_2 r0 *1 0,0
Xsky130_fd_sc_hd__nand2b_1_2 state[2] state[3] VSS VDD VDD \_0146_
+ sky130_fd_sc_hd__nand2b_1
* cell instance sky130_fd_sc_hd__nand2b_1_3 r0 *1 0,0
Xsky130_fd_sc_hd__nand2b_1_3 j[0] j[1] VSS VDD VDD \_0161_
+ sky130_fd_sc_hd__nand2b_1
* cell instance sky130_fd_sc_hd__nand2b_1_4 r0 *1 0,0
Xsky130_fd_sc_hd__nand2b_1_4 state[4] \_0144_ VSS VDD VDD \_0002_
+ sky130_fd_sc_hd__nand2b_1
* cell instance sky130_fd_sc_hd__nand2b_1_5 r0 *1 0,0
Xsky130_fd_sc_hd__nand2b_1_5 start state[0] VSS VDD VDD \_0144_
+ sky130_fd_sc_hd__nand2b_1
* cell instance sky130_fd_sc_hd__nand2b_1_6 r0 *1 0,0
Xsky130_fd_sc_hd__nand2b_1_6 \_0309_ \_0310_ VSS VDD VDD \_0416_
+ sky130_fd_sc_hd__nand2b_1
* cell instance sky130_fd_sc_hd__nand2b_1_7 r0 *1 0,0
Xsky130_fd_sc_hd__nand2b_1_7 mod_r[5] \_0246_ VSS VDD VDD \_0247_
+ sky130_fd_sc_hd__nand2b_1
* cell instance sky130_fd_sc_hd__nand2b_1_8 r0 *1 0,0
Xsky130_fd_sc_hd__nand2b_1_8 mod_r[6] \_0246_ VSS VDD VDD \_0303_
+ sky130_fd_sc_hd__nand2b_1
* cell instance sky130_fd_sc_hd__nand2b_1_9 r0 *1 0,0
Xsky130_fd_sc_hd__nand2b_1_9 \_0271_ \_0382_ VSS VDD VDD \_0383_
+ sky130_fd_sc_hd__nand2b_1
* cell instance sky130_fd_sc_hd__nand2b_1_10 r0 *1 0,0
Xsky130_fd_sc_hd__nand2b_1_10 \_0278_ \_0362_ VSS VDD VDD \_0363_
+ sky130_fd_sc_hd__nand2b_1
* cell instance sky130_fd_sc_hd__nand2b_1_11 r0 *1 0,0
Xsky130_fd_sc_hd__nand2b_1_11 \_0340_ \_0345_ VSS VDD VDD \_0346_
+ sky130_fd_sc_hd__nand2b_1
* cell instance sky130_fd_sc_hd__nand2b_1_12 r0 *1 0,0
Xsky130_fd_sc_hd__nand2b_1_12 \_0285_ \_0522_ VSS VDD VDD \_0523_
+ sky130_fd_sc_hd__nand2b_1
* cell instance sky130_fd_sc_hd__nand3_1_0 r0 *1 0,0
Xsky130_fd_sc_hd__nand3_1_0 j[3] \_0146_ \_0157_ VSS VDD VDD \_0158_
+ sky130_fd_sc_hd__nand3_1
* cell instance sky130_fd_sc_hd__nand3_1_1 r0 *1 0,0
Xsky130_fd_sc_hd__nand3_1_1 \_0129_ \_0132_ \_0531_ VSS VDD VDD \_0540_
+ sky130_fd_sc_hd__nand3_1
* cell instance sky130_fd_sc_hd__nand3_1_2 r0 *1 0,0
Xsky130_fd_sc_hd__nand3_1_2 \_0141_ \_0142_ net6 VSS VDD VDD \_0005_
+ sky130_fd_sc_hd__nand3_1
* cell instance sky130_fd_sc_hd__nand3_1_3 r0 *1 0,0
Xsky130_fd_sc_hd__nand3_1_3 state[5] \_0131_ exp_r[15] VSS VDD VDD \_0142_
+ sky130_fd_sc_hd__nand3_1
* cell instance sky130_fd_sc_hd__nand3_1_4 r0 *1 0,0
Xsky130_fd_sc_hd__nand3_1_4 exp_r[15] \_0136_ \_0511_ VSS VDD VDD \_0512_
+ sky130_fd_sc_hd__nand3_1
* cell instance sky130_fd_sc_hd__nand3_1_5 r0 *1 0,0
Xsky130_fd_sc_hd__nand3_1_5 mm_p[0] mm_a[15] mm_b[1] VSS VDD VDD \_0200_
+ sky130_fd_sc_hd__nand3_1
* cell instance sky130_fd_sc_hd__nand3_1_6 r0 *1 0,0
Xsky130_fd_sc_hd__nand3_1_6 mm_p[1] mm_a[15] mm_b[2] VSS VDD VDD \_0199_
+ sky130_fd_sc_hd__nand3_1
* cell instance sky130_fd_sc_hd__nand3_1_7 r0 *1 0,0
Xsky130_fd_sc_hd__nand3_1_7 \_0303_ \_0323_ \_0324_ VSS VDD VDD \_0392_
+ sky130_fd_sc_hd__nand3_1
* cell instance sky130_fd_sc_hd__nand3_1_8 r0 *1 0,0
Xsky130_fd_sc_hd__nand3_1_8 \_0241_ \_0269_ \_0270_ VSS VDD VDD \_0382_
+ sky130_fd_sc_hd__nand3_1
* cell instance sky130_fd_sc_hd__nand3_1_9 r0 *1 0,0
Xsky130_fd_sc_hd__nand3_1_9 \_0344_ \_0379_ \_0380_ VSS VDD VDD \_0381_
+ sky130_fd_sc_hd__nand3_1
* cell instance sky130_fd_sc_hd__nand3_1_10 r0 *1 0,0
Xsky130_fd_sc_hd__nand3_1_10 \_0233_ \_0276_ \_0277_ VSS VDD VDD \_0362_
+ sky130_fd_sc_hd__nand3_1
* cell instance sky130_fd_sc_hd__nand3_1_11 r0 *1 0,0
Xsky130_fd_sc_hd__nand3_1_11 mm_p[12] mm_a[15] mm_b[13] VSS VDD VDD \_0169_
+ sky130_fd_sc_hd__nand3_1
* cell instance sky130_fd_sc_hd__nand3_1_12 r0 *1 0,0
Xsky130_fd_sc_hd__nand3_1_12 mm_p[14] mm_a[15] mm_b[15] VSS VDD VDD \_0164_
+ sky130_fd_sc_hd__nand3_1
* cell instance sky130_fd_sc_hd__nand3_1_13 r0 *1 0,0
Xsky130_fd_sc_hd__nand3_1_13 \_0292_ \_0338_ \_0339_ VSS VDD VDD \_0345_
+ sky130_fd_sc_hd__nand3_1
* cell instance sky130_fd_sc_hd__nand3_1_14 r0 *1 0,0
Xsky130_fd_sc_hd__nand3_1_14 \_0226_ \_0282_ \_0284_ VSS VDD VDD \_0522_
+ sky130_fd_sc_hd__nand3_1
* cell instance sky130_fd_sc_hd__nand3b_1_0 r0 *1 0,0
Xsky130_fd_sc_hd__nand3b_1_0 j[3] \_0155_ state[2] VSS VDD VDD \_0156_
+ sky130_fd_sc_hd__nand3b_1
* cell instance sky130_fd_sc_hd__nand3b_1_1 r0 *1 0,0
Xsky130_fd_sc_hd__nand3b_1_1 outer[1] \_0133_ outer[0] VSS VDD VDD \_0134_
+ sky130_fd_sc_hd__nand3b_1
* cell instance sky130_fd_sc_hd__nand3b_1_2 r0 *1 0,0
Xsky130_fd_sc_hd__nand3b_1_2 \_0325_ \_0344_ \_0392_ VSS VDD VDD \_0393_
+ sky130_fd_sc_hd__nand3b_1
* cell instance sky130_fd_sc_hd__nand3b_1_3 r0 *1 0,0
Xsky130_fd_sc_hd__nand3b_1_3 \_0335_ \_0344_ \_0359_ VSS VDD VDD \_0360_
+ sky130_fd_sc_hd__nand3b_1
* cell instance sky130_fd_sc_hd__nor2_1_0 r0 *1 0,0
Xsky130_fd_sc_hd__nor2_1_0 \_0529_ \_0532_ VSS VDD VDD \_0114_
+ sky130_fd_sc_hd__nor2_1
* cell instance sky130_fd_sc_hd__nor2_1_1 r0 *1 0,0
Xsky130_fd_sc_hd__nor2_1_1 \_0529_ \_0534_ VSS VDD VDD \_0115_
+ sky130_fd_sc_hd__nor2_1
* cell instance sky130_fd_sc_hd__nor2_1_2 r0 *1 0,0
Xsky130_fd_sc_hd__nor2_1_2 \_0529_ \_0537_ VSS VDD VDD \_0118_
+ sky130_fd_sc_hd__nor2_1
* cell instance sky130_fd_sc_hd__nor2_1_3 r0 *1 0,0
Xsky130_fd_sc_hd__nor2_1_3 \_0531_ \_0533_ VSS VDD VDD \_0534_
+ sky130_fd_sc_hd__nor2_1
* cell instance sky130_fd_sc_hd__nor2_1_4 r0 *1 0,0
Xsky130_fd_sc_hd__nor2_1_4 outer[0] \_0442_ VSS VDD VDD \_0530_
+ sky130_fd_sc_hd__nor2_1
* cell instance sky130_fd_sc_hd__nor2_1_5 r0 *1 0,0
Xsky130_fd_sc_hd__nor2_1_5 \_0529_ \_0541_ VSS VDD VDD \_0542_
+ sky130_fd_sc_hd__nor2_1
* cell instance sky130_fd_sc_hd__nor2_1_6 r0 *1 0,0
Xsky130_fd_sc_hd__nor2_1_6 state[2] j[0] VSS VDD VDD \_0162_
+ sky130_fd_sc_hd__nor2_1
* cell instance sky130_fd_sc_hd__nor2_1_7 r0 *1 0,0
Xsky130_fd_sc_hd__nor2_1_7 state[5] \_0509_ VSS VDD VDD \_0510_
+ sky130_fd_sc_hd__nor2_1
* cell instance sky130_fd_sc_hd__nor2_1_8 r0 *1 0,0
Xsky130_fd_sc_hd__nor2_1_8 state[1] \_0143_ VSS VDD VDD \_0529_
+ sky130_fd_sc_hd__nor2_1
* cell instance sky130_fd_sc_hd__nor2_1_9 r0 *1 0,0
Xsky130_fd_sc_hd__nor2_1_9 mm_p[0] \_0440_ VSS VDD VDD \_0441_
+ sky130_fd_sc_hd__nor2_1
* cell instance sky130_fd_sc_hd__nor2_1_10 r0 *1 0,0
Xsky130_fd_sc_hd__nor2_1_10 mod_r[0] \_0257_ VSS VDD VDD \_0431_
+ sky130_fd_sc_hd__nor2_1
* cell instance sky130_fd_sc_hd__nor2_1_11 r0 *1 0,0
Xsky130_fd_sc_hd__nor2_1_11 \_0255_ \_0344_ VSS VDD VDD \_0424_
+ sky130_fd_sc_hd__nor2_1
* cell instance sky130_fd_sc_hd__nor2_1_12 r0 *1 0,0
Xsky130_fd_sc_hd__nor2_1_12 \_0311_ \_0317_ VSS VDD VDD \_0318_
+ sky130_fd_sc_hd__nor2_1
* cell instance sky130_fd_sc_hd__nor2_1_13 r0 *1 0,0
Xsky130_fd_sc_hd__nor2_1_13 mod_r[2] \_0255_ VSS VDD VDD \_0311_
+ sky130_fd_sc_hd__nor2_1
* cell instance sky130_fd_sc_hd__nor2_1_14 r0 *1 0,0
Xsky130_fd_sc_hd__nor2_1_14 \_0496_ \_0498_ VSS VDD VDD \_0098_
+ sky130_fd_sc_hd__nor2_1
* cell instance sky130_fd_sc_hd__nor2_1_15 r0 *1 0,0
Xsky130_fd_sc_hd__nor2_1_15 mm_b[1] state[3] VSS VDD VDD \_0495_
+ sky130_fd_sc_hd__nor2_1
* cell instance sky130_fd_sc_hd__nor2_1_16 r0 *1 0,0
Xsky130_fd_sc_hd__nor2_1_16 mm_b[0] state[3] VSS VDD VDD \_0496_
+ sky130_fd_sc_hd__nor2_1
* cell instance sky130_fd_sc_hd__nor2_1_17 r0 *1 0,0
Xsky130_fd_sc_hd__nor2_1_17 mod_r[3] \_0254_ VSS VDD VDD \_0309_
+ sky130_fd_sc_hd__nor2_1
* cell instance sky130_fd_sc_hd__nor2_1_18 r0 *1 0,0
Xsky130_fd_sc_hd__nor2_1_18 mm_b[2] state[3] VSS VDD VDD \_0492_
+ sky130_fd_sc_hd__nor2_1
* cell instance sky130_fd_sc_hd__nor2_1_19 r0 *1 0,0
Xsky130_fd_sc_hd__nor2_1_19 \_0253_ \_0344_ VSS VDD VDD \_0411_
+ sky130_fd_sc_hd__nor2_1
* cell instance sky130_fd_sc_hd__nor2_1_20 r0 *1 0,0
Xsky130_fd_sc_hd__nor2_1_20 mm_b[4] state[3] VSS VDD VDD \_0486_
+ sky130_fd_sc_hd__nor2_1
* cell instance sky130_fd_sc_hd__nor2_1_21 r0 *1 0,0
Xsky130_fd_sc_hd__nor2_1_21 mod_r[4] \_0253_ VSS VDD VDD \_0307_
+ sky130_fd_sc_hd__nor2_1
* cell instance sky130_fd_sc_hd__nor2_1_22 r0 *1 0,0
Xsky130_fd_sc_hd__nor2_1_22 mm_b[3] state[3] VSS VDD VDD \_0489_
+ sky130_fd_sc_hd__nor2_1
* cell instance sky130_fd_sc_hd__nor2_1_23 r0 *1 0,0
Xsky130_fd_sc_hd__nor2_1_23 \_0197_ \_0203_ VSS VDD VDD \_0204_
+ sky130_fd_sc_hd__nor2_1
* cell instance sky130_fd_sc_hd__nor2_1_24 r0 *1 0,0
Xsky130_fd_sc_hd__nor2_1_24 \_0192_ \_0193_ VSS VDD VDD \_0194_
+ sky130_fd_sc_hd__nor2_1
* cell instance sky130_fd_sc_hd__nor2_1_25 r0 *1 0,0
Xsky130_fd_sc_hd__nor2_1_25 mm_b[5] state[3] VSS VDD VDD \_0483_
+ sky130_fd_sc_hd__nor2_1
* cell instance sky130_fd_sc_hd__nor2_1_26 r0 *1 0,0
Xsky130_fd_sc_hd__nor2_1_26 mm_b[6] state[3] VSS VDD VDD \_0480_
+ sky130_fd_sc_hd__nor2_1
* cell instance sky130_fd_sc_hd__nor2_1_27 r0 *1 0,0
Xsky130_fd_sc_hd__nor2_1_27 \_0189_ \_0190_ VSS VDD VDD \_0245_
+ sky130_fd_sc_hd__nor2_1
* cell instance sky130_fd_sc_hd__nor2_1_28 r0 *1 0,0
Xsky130_fd_sc_hd__nor2_1_28 mm_b[7] state[3] VSS VDD VDD \_0477_
+ sky130_fd_sc_hd__nor2_1
* cell instance sky130_fd_sc_hd__nor2_1_29 r0 *1 0,0
Xsky130_fd_sc_hd__nor2_1_29 \_0186_ \_0187_ VSS VDD VDD \_0188_
+ sky130_fd_sc_hd__nor2_1
* cell instance sky130_fd_sc_hd__nor2_1_30 r0 *1 0,0
Xsky130_fd_sc_hd__nor2_1_30 mod_r[7] \_0242_ VSS VDD VDD \_0302_
+ sky130_fd_sc_hd__nor2_1
* cell instance sky130_fd_sc_hd__nor2_1_31 r0 *1 0,0
Xsky130_fd_sc_hd__nor2_1_31 \_0239_ \_0344_ VSS VDD VDD \_0388_
+ sky130_fd_sc_hd__nor2_1
* cell instance sky130_fd_sc_hd__nor2_1_32 r0 *1 0,0
Xsky130_fd_sc_hd__nor2_1_32 \_0302_ \_0325_ VSS VDD VDD \_0326_
+ sky130_fd_sc_hd__nor2_1
* cell instance sky130_fd_sc_hd__nor2_1_33 r0 *1 0,0
Xsky130_fd_sc_hd__nor2_1_33 mod_r[7] \_0239_ VSS VDD VDD \_0240_
+ sky130_fd_sc_hd__nor2_1
* cell instance sky130_fd_sc_hd__nor2_1_34 r0 *1 0,0
Xsky130_fd_sc_hd__nor2_1_34 mod_r[8] \_0239_ VSS VDD VDD \_0300_
+ sky130_fd_sc_hd__nor2_1
* cell instance sky130_fd_sc_hd__nor2_1_35 r0 *1 0,0
Xsky130_fd_sc_hd__nor2_1_35 mm_b[9] state[3] VSS VDD VDD \_0471_
+ sky130_fd_sc_hd__nor2_1
* cell instance sky130_fd_sc_hd__nor2_1_36 r0 *1 0,0
Xsky130_fd_sc_hd__nor2_1_36 mod_r[8] \_0237_ VSS VDD VDD \_0238_
+ sky130_fd_sc_hd__nor2_1
* cell instance sky130_fd_sc_hd__nor2_1_37 r0 *1 0,0
Xsky130_fd_sc_hd__nor2_1_37 \_0238_ \_0271_ VSS VDD VDD \_0272_
+ sky130_fd_sc_hd__nor2_1
* cell instance sky130_fd_sc_hd__nor2_1_38 r0 *1 0,0
Xsky130_fd_sc_hd__nor2_1_38 mm_b[8] state[3] VSS VDD VDD \_0474_
+ sky130_fd_sc_hd__nor2_1
* cell instance sky130_fd_sc_hd__nor2_1_39 r0 *1 0,0
Xsky130_fd_sc_hd__nor2_1_39 mm_b[10] state[3] VSS VDD VDD \_0465_
+ sky130_fd_sc_hd__nor2_1
* cell instance sky130_fd_sc_hd__nor2_1_40 r0 *1 0,0
Xsky130_fd_sc_hd__nor2_1_40 mod_r[10] \_0234_ VSS VDD VDD \_0295_
+ sky130_fd_sc_hd__nor2_1
* cell instance sky130_fd_sc_hd__nor2_1_41 r0 *1 0,0
Xsky130_fd_sc_hd__nor2_1_41 \_0333_ \_0366_ VSS VDD VDD \_0367_
+ sky130_fd_sc_hd__nor2_1
* cell instance sky130_fd_sc_hd__nor2_1_42 r0 *1 0,0
Xsky130_fd_sc_hd__nor2_1_42 mod_r[9] \_0234_ VSS VDD VDD \_0235_
+ sky130_fd_sc_hd__nor2_1
* cell instance sky130_fd_sc_hd__nor2_1_43 r0 *1 0,0
Xsky130_fd_sc_hd__nor2_1_43 mm_b[11] state[3] VSS VDD VDD \_0462_
+ sky130_fd_sc_hd__nor2_1
* cell instance sky130_fd_sc_hd__nor2_1_44 r0 *1 0,0
Xsky130_fd_sc_hd__nor2_1_44 \_0174_ \_0175_ VSS VDD VDD \_0176_
+ sky130_fd_sc_hd__nor2_1
* cell instance sky130_fd_sc_hd__nor2_1_45 r0 *1 0,0
Xsky130_fd_sc_hd__nor2_1_45 mod_r[11] \_0232_ VSS VDD VDD \_0294_
+ sky130_fd_sc_hd__nor2_1
* cell instance sky130_fd_sc_hd__nor2_1_46 r0 *1 0,0
Xsky130_fd_sc_hd__nor2_1_46 \_0232_ \_0344_ VSS VDD VDD \_0368_
+ sky130_fd_sc_hd__nor2_1
* cell instance sky130_fd_sc_hd__nor2_1_47 r0 *1 0,0
Xsky130_fd_sc_hd__nor2_1_47 mm_b[12] state[3] VSS VDD VDD \_0459_
+ sky130_fd_sc_hd__nor2_1
* cell instance sky130_fd_sc_hd__nor2_1_48 r0 *1 0,0
Xsky130_fd_sc_hd__nor2_1_48 \_0172_ \_0173_ VSS VDD VDD \_0229_
+ sky130_fd_sc_hd__nor2_1
* cell instance sky130_fd_sc_hd__nor2_1_49 r0 *1 0,0
Xsky130_fd_sc_hd__nor2_1_49 mod_r[12] \_0230_ VSS VDD VDD \_0293_
+ sky130_fd_sc_hd__nor2_1
* cell instance sky130_fd_sc_hd__nor2_1_50 r0 *1 0,0
Xsky130_fd_sc_hd__nor2_1_50 \_0172_ \_0216_ VSS VDD VDD \_0217_
+ sky130_fd_sc_hd__nor2_1
* cell instance sky130_fd_sc_hd__nor2_1_51 r0 *1 0,0
Xsky130_fd_sc_hd__nor2_1_51 mm_b[13] state[3] VSS VDD VDD \_0456_
+ sky130_fd_sc_hd__nor2_1
* cell instance sky130_fd_sc_hd__nor2_1_52 r0 *1 0,0
Xsky130_fd_sc_hd__nor2_1_52 mod_r[11] \_0230_ VSS VDD VDD \_0231_
+ sky130_fd_sc_hd__nor2_1
* cell instance sky130_fd_sc_hd__nor2_1_53 r0 *1 0,0
Xsky130_fd_sc_hd__nor2_1_53 mm_b[15] state[3] VSS VDD VDD \_0468_
+ sky130_fd_sc_hd__nor2_1
* cell instance sky130_fd_sc_hd__nor2_1_54 r0 *1 0,0
Xsky130_fd_sc_hd__nor2_1_54 mm_b[14] state[3] VSS VDD VDD \_0453_
+ sky130_fd_sc_hd__nor2_1
* cell instance sky130_fd_sc_hd__nor2_1_55 r0 *1 0,0
Xsky130_fd_sc_hd__nor2_1_55 mod_r[12] \_0227_ VSS VDD VDD \_0228_
+ sky130_fd_sc_hd__nor2_1
* cell instance sky130_fd_sc_hd__nor2_1_56 r0 *1 0,0
Xsky130_fd_sc_hd__nor2_1_56 mod_r[14] \_0225_ VSS VDD VDD \_0291_
+ sky130_fd_sc_hd__nor2_1
* cell instance sky130_fd_sc_hd__nor2_1_57 r0 *1 0,0
Xsky130_fd_sc_hd__nor2_1_57 \_0280_ \_0356_ VSS VDD VDD \_0357_
+ sky130_fd_sc_hd__nor2_1
* cell instance sky130_fd_sc_hd__nor2_1_58 r0 *1 0,0
Xsky130_fd_sc_hd__nor2_1_58 \_0289_ \_0354_ VSS VDD VDD \_0355_
+ sky130_fd_sc_hd__nor2_1
* cell instance sky130_fd_sc_hd__nor2_1_59 r0 *1 0,0
Xsky130_fd_sc_hd__nor2_1_59 mm_p[15] \_0220_ VSS VDD VDD \_0221_
+ sky130_fd_sc_hd__nor2_1
* cell instance sky130_fd_sc_hd__nor2_1_60 r0 *1 0,0
Xsky130_fd_sc_hd__nor2_1_60 \_0291_ \_0340_ VSS VDD VDD \_0341_
+ sky130_fd_sc_hd__nor2_1
* cell instance sky130_fd_sc_hd__nor2_1_61 r0 *1 0,0
Xsky130_fd_sc_hd__nor2_1_61 \_0289_ \_0347_ VSS VDD VDD \_0348_
+ sky130_fd_sc_hd__nor2_1
* cell instance sky130_fd_sc_hd__nor2_1_62 r0 *1 0,0
Xsky130_fd_sc_hd__nor2_1_62 mod_r[15] \_0221_ VSS VDD VDD \_0286_
+ sky130_fd_sc_hd__nor2_1
* cell instance sky130_fd_sc_hd__nor2_2_0 r0 *1 0,0
Xsky130_fd_sc_hd__nor2_2_0 state[2] state[3] VSS VDD VDD \_0140_
+ sky130_fd_sc_hd__nor2_2
* cell instance sky130_fd_sc_hd__nor2b_1_0 r0 *1 0,0
Xsky130_fd_sc_hd__nor2b_1_0 \_0195_ \_0196_ VSS VDD VDD \_0252_
+ sky130_fd_sc_hd__nor2b_1
* cell instance sky130_fd_sc_hd__nor2b_1_1 r0 *1 0,0
Xsky130_fd_sc_hd__nor2b_1_1 \_0305_ \_0306_ VSS VDD VDD \_0403_
+ sky130_fd_sc_hd__nor2b_1
* cell instance sky130_fd_sc_hd__nor2b_1_2 r0 *1 0,0
Xsky130_fd_sc_hd__nor2b_1_2 \_0167_ \_0168_ VSS VDD VDD \_0224_
+ sky130_fd_sc_hd__nor2b_1
* cell instance sky130_fd_sc_hd__nor3_1_0 r0 *1 0,0
Xsky130_fd_sc_hd__nor3_1_0 outer[2] outer[3] outer[4] VSS VDD VDD \_0133_
+ sky130_fd_sc_hd__nor3_1
* cell instance sky130_fd_sc_hd__nor3_1_1 r0 *1 0,0
Xsky130_fd_sc_hd__nor3_1_1 j[0] j[1] j[2] VSS VDD VDD \_0155_
+ sky130_fd_sc_hd__nor3_1
* cell instance sky130_fd_sc_hd__nor3_1_2 r0 *1 0,0
Xsky130_fd_sc_hd__nor3_1_2 \_0258_ net4 \_0431_ VSS VDD VDD \_0432_
+ sky130_fd_sc_hd__nor3_1
* cell instance sky130_fd_sc_hd__nor3_1_3 r0 *1 0,0
Xsky130_fd_sc_hd__nor3_1_3 mod_r[5] \_0207_ \_0249_ VSS VDD VDD \_0305_
+ sky130_fd_sc_hd__nor3_1
* cell instance sky130_fd_sc_hd__nor3_1_4 r0 *1 0,0
Xsky130_fd_sc_hd__nor3_1_4 \_0295_ \_0331_ \_0332_ VSS VDD VDD \_0366_
+ sky130_fd_sc_hd__nor3_1
* cell instance sky130_fd_sc_hd__nor3_1_5 r0 *1 0,0
Xsky130_fd_sc_hd__nor3_1_5 \_0231_ \_0278_ \_0279_ VSS VDD VDD \_0356_
+ sky130_fd_sc_hd__nor3_1
* cell instance sky130_fd_sc_hd__nor3_1_6 r0 *1 0,0
Xsky130_fd_sc_hd__nor3_1_6 \_0228_ \_0280_ \_0281_ VSS VDD VDD \_0349_
+ sky130_fd_sc_hd__nor3_1
* cell instance sky130_fd_sc_hd__nor4_1_0 r0 *1 0,0
Xsky130_fd_sc_hd__nor4_1_0 outer[0] outer[1] outer[2] \_0442_ VSS VDD VDD
+ \_0531_ sky130_fd_sc_hd__nor4_1
* cell instance sky130_fd_sc_hd__o211a_1_0 r0 *1 0,0
Xsky130_fd_sc_hd__o211a_1_0 \_0238_ \_0271_ \_0273_ \_0236_ VSS VDD VDD \_0274_
+ sky130_fd_sc_hd__o211a_1
* cell instance sky130_fd_sc_hd__o211ai_1_0 r0 *1 0,0
Xsky130_fd_sc_hd__o211ai_1_0 \_0254_ \_0344_ \_0418_ net4 VSS VDD VDD \_0421_
+ sky130_fd_sc_hd__o211ai_1
* cell instance sky130_fd_sc_hd__o211ai_1_1 r0 *1 0,0
Xsky130_fd_sc_hd__o211ai_1_1 \_0250_ \_0344_ \_0405_ net4 VSS VDD VDD \_0408_
+ sky130_fd_sc_hd__o211ai_1
* cell instance sky130_fd_sc_hd__o211ai_1_2 r0 *1 0,0
Xsky130_fd_sc_hd__o211ai_1_2 \_0242_ \_0344_ \_0393_ net4 VSS VDD VDD \_0395_
+ sky130_fd_sc_hd__o211ai_1
* cell instance sky130_fd_sc_hd__o211ai_1_3 r0 *1 0,0
Xsky130_fd_sc_hd__o211ai_1_3 \_0237_ \_0344_ \_0381_ net4 VSS VDD VDD \_0385_
+ sky130_fd_sc_hd__o211ai_1
* cell instance sky130_fd_sc_hd__o211ai_1_4 r0 *1 0,0
Xsky130_fd_sc_hd__o211ai_1_4 \_0234_ \_0344_ \_0374_ net4 VSS VDD VDD \_0375_
+ sky130_fd_sc_hd__o211ai_1
* cell instance sky130_fd_sc_hd__o211ai_1_5 r0 *1 0,0
Xsky130_fd_sc_hd__o211ai_1_5 \_0235_ \_0274_ \_0275_ \_0233_ VSS VDD VDD
+ \_0276_ sky130_fd_sc_hd__o211ai_1
* cell instance sky130_fd_sc_hd__o211ai_1_6 r0 *1 0,0
Xsky130_fd_sc_hd__o211ai_1_6 \_0230_ \_0344_ \_0360_ net4 VSS VDD VDD \_0361_
+ sky130_fd_sc_hd__o211ai_1
* cell instance sky130_fd_sc_hd__o21a_1_0 r0 *1 0,0
Xsky130_fd_sc_hd__o21a_1_0 \_0289_ \_0435_ \_0312_ VSS VDD VDD \_0436_
+ sky130_fd_sc_hd__o21a_1
* cell instance sky130_fd_sc_hd__o21a_1_1 r0 *1 0,0
Xsky130_fd_sc_hd__o21a_1_1 \_0295_ \_0331_ \_0332_ VSS VDD VDD \_0333_
+ sky130_fd_sc_hd__o21a_1
* cell instance sky130_fd_sc_hd__o21a_1_2 r0 *1 0,0
Xsky130_fd_sc_hd__o21a_1_2 \_0294_ \_0333_ \_0334_ VSS VDD VDD \_0335_
+ sky130_fd_sc_hd__o21a_1
* cell instance sky130_fd_sc_hd__o21a_1_3 r0 *1 0,0
Xsky130_fd_sc_hd__o21a_1_3 \_0231_ \_0278_ \_0279_ VSS VDD VDD \_0280_
+ sky130_fd_sc_hd__o21a_1
* cell instance sky130_fd_sc_hd__o21ai_0_0 r0 *1 0,0
Xsky130_fd_sc_hd__o21ai_0_0 \_0442_ \_0443_ \_0444_ VSS VDD VDD \_0048_
+ sky130_fd_sc_hd__o21ai_0
* cell instance sky130_fd_sc_hd__o21ai_0_1 r0 *1 0,0
Xsky130_fd_sc_hd__o21ai_0_1 \_0442_ \_0543_ \_0544_ VSS VDD VDD \_0121_
+ sky130_fd_sc_hd__o21ai_0
* cell instance sky130_fd_sc_hd__o21ai_0_2 r0 *1 0,0
Xsky130_fd_sc_hd__o21ai_0_2 \_0130_ \_0146_ \_0154_ VSS VDD VDD \_0013_
+ sky130_fd_sc_hd__o21ai_0
* cell instance sky130_fd_sc_hd__o21ai_0_3 r0 *1 0,0
Xsky130_fd_sc_hd__o21ai_0_3 \_0442_ \_0527_ \_0528_ VSS VDD VDD \_0112_
+ sky130_fd_sc_hd__o21ai_0
* cell instance sky130_fd_sc_hd__o21ai_0_4 r0 *1 0,0
Xsky130_fd_sc_hd__o21ai_0_4 \_0432_ \_0433_ \_0428_ VSS VDD VDD \_0031_
+ sky130_fd_sc_hd__o21ai_0
* cell instance sky130_fd_sc_hd__o21ai_0_5 r0 *1 0,0
Xsky130_fd_sc_hd__o21ai_0_5 state[5] state[0] \_0144_ VSS VDD VDD \_0438_
+ sky130_fd_sc_hd__o21ai_0
* cell instance sky130_fd_sc_hd__o21ai_0_6 r0 *1 0,0
Xsky130_fd_sc_hd__o21ai_0_6 net4 \_0426_ state[2] VSS VDD VDD \_0427_
+ sky130_fd_sc_hd__o21ai_0
* cell instance sky130_fd_sc_hd__o21ai_0_7 r0 *1 0,0
Xsky130_fd_sc_hd__o21ai_0_7 \_0425_ \_0427_ \_0422_ VSS VDD VDD \_0030_
+ sky130_fd_sc_hd__o21ai_0
* cell instance sky130_fd_sc_hd__o21ai_0_8 r0 *1 0,0
Xsky130_fd_sc_hd__o21ai_0_8 \_0442_ \_0525_ \_0526_ VSS VDD VDD \_0111_
+ sky130_fd_sc_hd__o21ai_0
* cell instance sky130_fd_sc_hd__o21ai_0_9 r0 *1 0,0
Xsky130_fd_sc_hd__o21ai_0_9 \_0289_ \_0430_ state[2] VSS VDD VDD \_0433_
+ sky130_fd_sc_hd__o21ai_0
* cell instance sky130_fd_sc_hd__o21ai_0_10 r0 *1 0,0
Xsky130_fd_sc_hd__o21ai_0_10 \_0442_ \_0445_ \_0446_ VSS VDD VDD \_0049_
+ sky130_fd_sc_hd__o21ai_0
* cell instance sky130_fd_sc_hd__o21ai_0_11 r0 *1 0,0
Xsky130_fd_sc_hd__o21ai_0_11 \_0436_ \_0437_ \_0434_ VSS VDD VDD \_0032_
+ sky130_fd_sc_hd__o21ai_0
* cell instance sky130_fd_sc_hd__o21ai_0_12 r0 *1 0,0
Xsky130_fd_sc_hd__o21ai_0_12 \_0130_ mm_phase state[3] VSS VDD VDD \_0497_
+ sky130_fd_sc_hd__o21ai_0
* cell instance sky130_fd_sc_hd__o21ai_0_13 r0 *1 0,0
Xsky130_fd_sc_hd__o21ai_0_13 \_0442_ \_0447_ \_0448_ VSS VDD VDD \_0050_
+ sky130_fd_sc_hd__o21ai_0
* cell instance sky130_fd_sc_hd__o21ai_0_14 r0 *1 0,0
Xsky130_fd_sc_hd__o21ai_0_14 \_0442_ \_0517_ \_0518_ VSS VDD VDD \_0109_
+ sky130_fd_sc_hd__o21ai_0
* cell instance sky130_fd_sc_hd__o21ai_0_15 r0 *1 0,0
Xsky130_fd_sc_hd__o21ai_0_15 \_0200_ \_0201_ \_0199_ VSS VDD VDD \_0202_
+ sky130_fd_sc_hd__o21ai_0
* cell instance sky130_fd_sc_hd__o21ai_0_16 r0 *1 0,0
Xsky130_fd_sc_hd__o21ai_0_16 \_0442_ \_0449_ \_0450_ VSS VDD VDD \_0051_
+ sky130_fd_sc_hd__o21ai_0
* cell instance sky130_fd_sc_hd__o21ai_0_17 r0 *1 0,0
Xsky130_fd_sc_hd__o21ai_0_17 \_0442_ \_0515_ \_0516_ VSS VDD VDD \_0107_
+ sky130_fd_sc_hd__o21ai_0
* cell instance sky130_fd_sc_hd__o21ai_0_18 r0 *1 0,0
Xsky130_fd_sc_hd__o21ai_0_18 net4 \_0414_ state[2] VSS VDD VDD \_0415_
+ sky130_fd_sc_hd__o21ai_0
* cell instance sky130_fd_sc_hd__o21ai_0_19 r0 *1 0,0
Xsky130_fd_sc_hd__o21ai_0_19 \_0305_ \_0321_ \_0306_ VSS VDD VDD \_0322_
+ sky130_fd_sc_hd__o21ai_0
* cell instance sky130_fd_sc_hd__o21ai_0_20 r0 *1 0,0
Xsky130_fd_sc_hd__o21ai_0_20 \_0412_ \_0415_ \_0409_ VSS VDD VDD \_0028_
+ sky130_fd_sc_hd__o21ai_0
* cell instance sky130_fd_sc_hd__o21ai_0_21 r0 *1 0,0
Xsky130_fd_sc_hd__o21ai_0_21 \_0207_ \_0249_ mod_r[5] VSS VDD VDD \_0306_
+ sky130_fd_sc_hd__o21ai_0
* cell instance sky130_fd_sc_hd__o21ai_0_22 r0 *1 0,0
Xsky130_fd_sc_hd__o21ai_0_22 \_0442_ \_0499_ \_0500_ VSS VDD VDD \_0099_
+ sky130_fd_sc_hd__o21ai_0
* cell instance sky130_fd_sc_hd__o21ai_0_23 r0 *1 0,0
Xsky130_fd_sc_hd__o21ai_0_23 \_0442_ \_0513_ \_0514_ VSS VDD VDD \_0106_
+ sky130_fd_sc_hd__o21ai_0
* cell instance sky130_fd_sc_hd__o21ai_0_24 r0 *1 0,0
Xsky130_fd_sc_hd__o21ai_0_24 \_0442_ \_0501_ \_0502_ VSS VDD VDD \_0101_
+ sky130_fd_sc_hd__o21ai_0
* cell instance sky130_fd_sc_hd__o21ai_0_25 r0 *1 0,0
Xsky130_fd_sc_hd__o21ai_0_25 \_0442_ \_0507_ \_0508_ VSS VDD VDD \_0104_
+ sky130_fd_sc_hd__o21ai_0
* cell instance sky130_fd_sc_hd__o21ai_0_26 r0 *1 0,0
Xsky130_fd_sc_hd__o21ai_0_26 net4 \_0389_ state[2] VSS VDD VDD \_0391_
+ sky130_fd_sc_hd__o21ai_0
* cell instance sky130_fd_sc_hd__o21ai_0_27 r0 *1 0,0
Xsky130_fd_sc_hd__o21ai_0_27 \_0390_ \_0391_ \_0386_ VSS VDD VDD \_0024_
+ sky130_fd_sc_hd__o21ai_0
* cell instance sky130_fd_sc_hd__o21ai_0_28 r0 *1 0,0
Xsky130_fd_sc_hd__o21ai_0_28 \_0442_ \_0505_ \_0506_ VSS VDD VDD \_0103_
+ sky130_fd_sc_hd__o21ai_0
* cell instance sky130_fd_sc_hd__o21ai_0_29 r0 *1 0,0
Xsky130_fd_sc_hd__o21ai_0_29 \_0442_ \_0503_ \_0504_ VSS VDD VDD \_0102_
+ sky130_fd_sc_hd__o21ai_0
* cell instance sky130_fd_sc_hd__o21ai_0_30 r0 *1 0,0
Xsky130_fd_sc_hd__o21ai_0_30 net4 \_0371_ state[2] VSS VDD VDD \_0372_
+ sky130_fd_sc_hd__o21ai_0
* cell instance sky130_fd_sc_hd__o21ai_0_31 r0 *1 0,0
Xsky130_fd_sc_hd__o21ai_0_31 \_0369_ \_0372_ \_0365_ VSS VDD VDD \_0021_
+ sky130_fd_sc_hd__o21ai_0
* cell instance sky130_fd_sc_hd__o21ai_0_32 r0 *1 0,0
Xsky130_fd_sc_hd__o21ai_0_32 \_0167_ \_0218_ \_0168_ VSS VDD VDD \_0219_
+ sky130_fd_sc_hd__o21ai_0
* cell instance sky130_fd_sc_hd__o21ai_0_33 r0 *1 0,0
Xsky130_fd_sc_hd__o21ai_0_33 \_0166_ \_0219_ \_0164_ VSS VDD VDD \_0220_
+ sky130_fd_sc_hd__o21ai_0
* cell instance sky130_fd_sc_hd__o21ai_0_34 r0 *1 0,0
Xsky130_fd_sc_hd__o21ai_0_34 mod_r[14] \_0283_ \_0287_ VSS VDD VDD \_0288_
+ sky130_fd_sc_hd__o21ai_0
* cell instance sky130_fd_sc_hd__o21ai_0_35 r0 *1 0,0
Xsky130_fd_sc_hd__o21ai_0_35 net4 \_0357_ state[2] VSS VDD VDD \_0358_
+ sky130_fd_sc_hd__o21ai_0
* cell instance sky130_fd_sc_hd__o21ai_0_36 r0 *1 0,0
Xsky130_fd_sc_hd__o21ai_0_36 \_0228_ \_0280_ \_0281_ VSS VDD VDD \_0282_
+ sky130_fd_sc_hd__o21ai_0
* cell instance sky130_fd_sc_hd__o21ai_0_37 r0 *1 0,0
Xsky130_fd_sc_hd__o21ai_0_37 \_0341_ \_0342_ \_0519_ VSS VDD VDD \_0520_
+ sky130_fd_sc_hd__o21ai_0
* cell instance sky130_fd_sc_hd__o21ai_0_38 r0 *1 0,0
Xsky130_fd_sc_hd__o21ai_0_38 \_0355_ \_0358_ \_0352_ VSS VDD VDD \_0019_
+ sky130_fd_sc_hd__o21ai_0
* cell instance sky130_fd_sc_hd__o21ai_0_39 r0 *1 0,0
Xsky130_fd_sc_hd__o21ai_0_39 \_0348_ \_0351_ \_0163_ VSS VDD VDD \_0018_
+ sky130_fd_sc_hd__o21ai_0
* cell instance sky130_fd_sc_hd__o21ai_0_40 r0 *1 0,0
Xsky130_fd_sc_hd__o21ai_0_40 net4 \_0350_ state[2] VSS VDD VDD \_0351_
+ sky130_fd_sc_hd__o21ai_0
* cell instance sky130_fd_sc_hd__o21ai_2_0 r0 *1 0,0
Xsky130_fd_sc_hd__o21ai_2_0 state[1] state[0] \_0144_ VSS VDD VDD \_0442_
+ sky130_fd_sc_hd__o21ai_2
* cell instance sky130_fd_sc_hd__o21bai_1_0 r0 *1 0,0
Xsky130_fd_sc_hd__o21bai_1_0 \_0302_ \_0325_ \_0327_ VSS VDD VDD \_0328_
+ sky130_fd_sc_hd__o21bai_1
* cell instance sky130_fd_sc_hd__o21bai_1_1 r0 *1 0,0
Xsky130_fd_sc_hd__o21bai_1_1 \_0293_ \_0335_ \_0337_ VSS VDD VDD \_0338_
+ sky130_fd_sc_hd__o21bai_1
* cell instance sky130_fd_sc_hd__o22ai_2_0 r0 *1 0,0
Xsky130_fd_sc_hd__o22ai_2_0 \_0341_ \_0342_ \_0343_ \_0222_ VSS VDD VDD \_0344_
+ sky130_fd_sc_hd__o22ai_2
* cell instance sky130_fd_sc_hd__o311a_1_0 r0 *1 0,0
Xsky130_fd_sc_hd__o311a_1_0 \_0309_ \_0311_ \_0317_ \_0310_ \_0308_ VSS VDD VDD
+ \_0320_ sky130_fd_sc_hd__o311a_1
* cell instance sky130_fd_sc_hd__o311ai_0_0 r0 *1 0,0
Xsky130_fd_sc_hd__o311ai_0_0 j[0] j[1] \_0139_ \_0146_ j[2] VSS VDD VDD \_0160_
+ sky130_fd_sc_hd__o311ai_0
* cell instance sky130_fd_sc_hd__o311ai_0_1 r0 *1 0,0
Xsky130_fd_sc_hd__o311ai_0_1 \_0305_ \_0307_ \_0320_ \_0306_ \_0304_ VSS VDD
+ VDD \_0323_ sky130_fd_sc_hd__o311ai_0
* cell instance sky130_fd_sc_hd__o31a_1_0 r0 *1 0,0
Xsky130_fd_sc_hd__o31a_1_0 outer[0] outer[1] \_0442_ outer[2] VSS VDD VDD
+ \_0533_ sky130_fd_sc_hd__o31a_1
* cell instance sky130_fd_sc_hd__o31a_1_1 r0 *1 0,0
Xsky130_fd_sc_hd__o31a_1_1 \_0285_ \_0286_ \_0288_ \_0223_ VSS VDD VDD \_0289_
+ sky130_fd_sc_hd__o31a_1
* cell instance sky130_fd_sc_hd__o31ai_1_0 r0 *1 0,0
Xsky130_fd_sc_hd__o31ai_1_0 \_0289_ \_0312_ \_0435_ state[2] VSS VDD VDD
+ \_0437_ sky130_fd_sc_hd__o31ai_1
* cell instance sky130_fd_sc_hd__o31ai_1_1 r0 *1 0,0
Xsky130_fd_sc_hd__o31ai_1_1 \_0309_ \_0311_ \_0317_ \_0310_ VSS VDD VDD \_0319_
+ sky130_fd_sc_hd__o31ai_1
* cell instance sky130_fd_sc_hd__o31ai_1_2 r0 *1 0,0
Xsky130_fd_sc_hd__o31ai_1_2 \_0171_ \_0172_ \_0216_ \_0169_ VSS VDD VDD \_0218_
+ sky130_fd_sc_hd__o31ai_1
* cell instance sky130_fd_sc_hd__o31ai_1_3 r0 *1 0,0
Xsky130_fd_sc_hd__o31ai_1_3 \_0285_ \_0286_ \_0288_ \_0223_ VSS VDD VDD \_0290_
+ sky130_fd_sc_hd__o31ai_1
* cell instance sky130_fd_sc_hd__or3_1_0 r0 *1 0,0
Xsky130_fd_sc_hd__or3_1_0 \_0294_ \_0333_ \_0334_ VSS VDD VDD \_0359_
+ sky130_fd_sc_hd__or3_1
* cell instance sky130_fd_sc_hd__or4_1_0 r0 *1 0,0
Xsky130_fd_sc_hd__or4_1_0 j[2] j[3] j[4] \_0137_ VSS VDD VDD \_0138_
+ sky130_fd_sc_hd__or4_1
* cell instance sky130_fd_sc_hd__tapvpwrvgnd_1_0 r0 *1 0,0
Xsky130_fd_sc_hd__tapvpwrvgnd_1_0 VSS VDD sky130_fd_sc_hd__tapvpwrvgnd_1
* cell instance sky130_fd_sc_hd__tapvpwrvgnd_1_1 r0 *1 0,0
Xsky130_fd_sc_hd__tapvpwrvgnd_1_1 VSS VDD sky130_fd_sc_hd__tapvpwrvgnd_1
* cell instance sky130_fd_sc_hd__tapvpwrvgnd_1_2 r0 *1 0,0
Xsky130_fd_sc_hd__tapvpwrvgnd_1_2 VSS VDD sky130_fd_sc_hd__tapvpwrvgnd_1
* cell instance sky130_fd_sc_hd__tapvpwrvgnd_1_3 r0 *1 0,0
Xsky130_fd_sc_hd__tapvpwrvgnd_1_3 VSS VDD sky130_fd_sc_hd__tapvpwrvgnd_1
* cell instance sky130_fd_sc_hd__tapvpwrvgnd_1_4 r0 *1 0,0
Xsky130_fd_sc_hd__tapvpwrvgnd_1_4 VSS VDD sky130_fd_sc_hd__tapvpwrvgnd_1
* cell instance sky130_fd_sc_hd__tapvpwrvgnd_1_5 r0 *1 0,0
Xsky130_fd_sc_hd__tapvpwrvgnd_1_5 VSS VDD sky130_fd_sc_hd__tapvpwrvgnd_1
* cell instance sky130_fd_sc_hd__tapvpwrvgnd_1_6 r0 *1 0,0
Xsky130_fd_sc_hd__tapvpwrvgnd_1_6 VSS VDD sky130_fd_sc_hd__tapvpwrvgnd_1
* cell instance sky130_fd_sc_hd__tapvpwrvgnd_1_7 r0 *1 0,0
Xsky130_fd_sc_hd__tapvpwrvgnd_1_7 VSS VDD sky130_fd_sc_hd__tapvpwrvgnd_1
* cell instance sky130_fd_sc_hd__tapvpwrvgnd_1_8 r0 *1 0,0
Xsky130_fd_sc_hd__tapvpwrvgnd_1_8 VSS VDD sky130_fd_sc_hd__tapvpwrvgnd_1
* cell instance sky130_fd_sc_hd__tapvpwrvgnd_1_9 r0 *1 0,0
Xsky130_fd_sc_hd__tapvpwrvgnd_1_9 VSS VDD sky130_fd_sc_hd__tapvpwrvgnd_1
* cell instance sky130_fd_sc_hd__tapvpwrvgnd_1_10 r0 *1 0,0
Xsky130_fd_sc_hd__tapvpwrvgnd_1_10 VSS VDD sky130_fd_sc_hd__tapvpwrvgnd_1
* cell instance sky130_fd_sc_hd__tapvpwrvgnd_1_11 r0 *1 0,0
Xsky130_fd_sc_hd__tapvpwrvgnd_1_11 VSS VDD sky130_fd_sc_hd__tapvpwrvgnd_1
* cell instance sky130_fd_sc_hd__tapvpwrvgnd_1_12 r0 *1 0,0
Xsky130_fd_sc_hd__tapvpwrvgnd_1_12 VSS VDD sky130_fd_sc_hd__tapvpwrvgnd_1
* cell instance sky130_fd_sc_hd__tapvpwrvgnd_1_13 r0 *1 0,0
Xsky130_fd_sc_hd__tapvpwrvgnd_1_13 VSS VDD sky130_fd_sc_hd__tapvpwrvgnd_1
* cell instance sky130_fd_sc_hd__tapvpwrvgnd_1_14 r0 *1 0,0
Xsky130_fd_sc_hd__tapvpwrvgnd_1_14 VSS VDD sky130_fd_sc_hd__tapvpwrvgnd_1
* cell instance sky130_fd_sc_hd__tapvpwrvgnd_1_15 r0 *1 0,0
Xsky130_fd_sc_hd__tapvpwrvgnd_1_15 VSS VDD sky130_fd_sc_hd__tapvpwrvgnd_1
* cell instance sky130_fd_sc_hd__tapvpwrvgnd_1_16 r0 *1 0,0
Xsky130_fd_sc_hd__tapvpwrvgnd_1_16 VSS VDD sky130_fd_sc_hd__tapvpwrvgnd_1
* cell instance sky130_fd_sc_hd__tapvpwrvgnd_1_17 r0 *1 0,0
Xsky130_fd_sc_hd__tapvpwrvgnd_1_17 VSS VDD sky130_fd_sc_hd__tapvpwrvgnd_1
* cell instance sky130_fd_sc_hd__tapvpwrvgnd_1_18 r0 *1 0,0
Xsky130_fd_sc_hd__tapvpwrvgnd_1_18 VSS VDD sky130_fd_sc_hd__tapvpwrvgnd_1
* cell instance sky130_fd_sc_hd__tapvpwrvgnd_1_19 r0 *1 0,0
Xsky130_fd_sc_hd__tapvpwrvgnd_1_19 VSS VDD sky130_fd_sc_hd__tapvpwrvgnd_1
* cell instance sky130_fd_sc_hd__tapvpwrvgnd_1_20 r0 *1 0,0
Xsky130_fd_sc_hd__tapvpwrvgnd_1_20 VSS VDD sky130_fd_sc_hd__tapvpwrvgnd_1
* cell instance sky130_fd_sc_hd__tapvpwrvgnd_1_21 r0 *1 0,0
Xsky130_fd_sc_hd__tapvpwrvgnd_1_21 VSS VDD sky130_fd_sc_hd__tapvpwrvgnd_1
* cell instance sky130_fd_sc_hd__tapvpwrvgnd_1_22 r0 *1 0,0
Xsky130_fd_sc_hd__tapvpwrvgnd_1_22 VSS VDD sky130_fd_sc_hd__tapvpwrvgnd_1
* cell instance sky130_fd_sc_hd__tapvpwrvgnd_1_23 r0 *1 0,0
Xsky130_fd_sc_hd__tapvpwrvgnd_1_23 VSS VDD sky130_fd_sc_hd__tapvpwrvgnd_1
* cell instance sky130_fd_sc_hd__tapvpwrvgnd_1_24 r0 *1 0,0
Xsky130_fd_sc_hd__tapvpwrvgnd_1_24 VSS VDD sky130_fd_sc_hd__tapvpwrvgnd_1
* cell instance sky130_fd_sc_hd__tapvpwrvgnd_1_25 r0 *1 0,0
Xsky130_fd_sc_hd__tapvpwrvgnd_1_25 VSS VDD sky130_fd_sc_hd__tapvpwrvgnd_1
* cell instance sky130_fd_sc_hd__tapvpwrvgnd_1_26 r0 *1 0,0
Xsky130_fd_sc_hd__tapvpwrvgnd_1_26 VSS VDD sky130_fd_sc_hd__tapvpwrvgnd_1
* cell instance sky130_fd_sc_hd__tapvpwrvgnd_1_27 r0 *1 0,0
Xsky130_fd_sc_hd__tapvpwrvgnd_1_27 VSS VDD sky130_fd_sc_hd__tapvpwrvgnd_1
* cell instance sky130_fd_sc_hd__tapvpwrvgnd_1_28 r0 *1 0,0
Xsky130_fd_sc_hd__tapvpwrvgnd_1_28 VSS VDD sky130_fd_sc_hd__tapvpwrvgnd_1
* cell instance sky130_fd_sc_hd__tapvpwrvgnd_1_29 r0 *1 0,0
Xsky130_fd_sc_hd__tapvpwrvgnd_1_29 VSS VDD sky130_fd_sc_hd__tapvpwrvgnd_1
* cell instance sky130_fd_sc_hd__tapvpwrvgnd_1_30 r0 *1 0,0
Xsky130_fd_sc_hd__tapvpwrvgnd_1_30 VSS VDD sky130_fd_sc_hd__tapvpwrvgnd_1
* cell instance sky130_fd_sc_hd__tapvpwrvgnd_1_31 r0 *1 0,0
Xsky130_fd_sc_hd__tapvpwrvgnd_1_31 VSS VDD sky130_fd_sc_hd__tapvpwrvgnd_1
* cell instance sky130_fd_sc_hd__tapvpwrvgnd_1_32 r0 *1 0,0
Xsky130_fd_sc_hd__tapvpwrvgnd_1_32 VSS VDD sky130_fd_sc_hd__tapvpwrvgnd_1
* cell instance sky130_fd_sc_hd__tapvpwrvgnd_1_33 r0 *1 0,0
Xsky130_fd_sc_hd__tapvpwrvgnd_1_33 VSS VDD sky130_fd_sc_hd__tapvpwrvgnd_1
* cell instance sky130_fd_sc_hd__tapvpwrvgnd_1_34 r0 *1 0,0
Xsky130_fd_sc_hd__tapvpwrvgnd_1_34 VSS VDD sky130_fd_sc_hd__tapvpwrvgnd_1
* cell instance sky130_fd_sc_hd__tapvpwrvgnd_1_35 r0 *1 0,0
Xsky130_fd_sc_hd__tapvpwrvgnd_1_35 VSS VDD sky130_fd_sc_hd__tapvpwrvgnd_1
* cell instance sky130_fd_sc_hd__tapvpwrvgnd_1_36 r0 *1 0,0
Xsky130_fd_sc_hd__tapvpwrvgnd_1_36 VSS VDD sky130_fd_sc_hd__tapvpwrvgnd_1
* cell instance sky130_fd_sc_hd__tapvpwrvgnd_1_37 r0 *1 0,0
Xsky130_fd_sc_hd__tapvpwrvgnd_1_37 VSS VDD sky130_fd_sc_hd__tapvpwrvgnd_1
* cell instance sky130_fd_sc_hd__tapvpwrvgnd_1_38 r0 *1 0,0
Xsky130_fd_sc_hd__tapvpwrvgnd_1_38 VSS VDD sky130_fd_sc_hd__tapvpwrvgnd_1
* cell instance sky130_fd_sc_hd__tapvpwrvgnd_1_39 r0 *1 0,0
Xsky130_fd_sc_hd__tapvpwrvgnd_1_39 VSS VDD sky130_fd_sc_hd__tapvpwrvgnd_1
* cell instance sky130_fd_sc_hd__tapvpwrvgnd_1_40 r0 *1 0,0
Xsky130_fd_sc_hd__tapvpwrvgnd_1_40 VSS VDD sky130_fd_sc_hd__tapvpwrvgnd_1
* cell instance sky130_fd_sc_hd__tapvpwrvgnd_1_41 r0 *1 0,0
Xsky130_fd_sc_hd__tapvpwrvgnd_1_41 VSS VDD sky130_fd_sc_hd__tapvpwrvgnd_1
* cell instance sky130_fd_sc_hd__tapvpwrvgnd_1_42 r0 *1 0,0
Xsky130_fd_sc_hd__tapvpwrvgnd_1_42 VSS VDD sky130_fd_sc_hd__tapvpwrvgnd_1
* cell instance sky130_fd_sc_hd__tapvpwrvgnd_1_43 r0 *1 0,0
Xsky130_fd_sc_hd__tapvpwrvgnd_1_43 VSS VDD sky130_fd_sc_hd__tapvpwrvgnd_1
* cell instance sky130_fd_sc_hd__tapvpwrvgnd_1_44 r0 *1 0,0
Xsky130_fd_sc_hd__tapvpwrvgnd_1_44 VSS VDD sky130_fd_sc_hd__tapvpwrvgnd_1
* cell instance sky130_fd_sc_hd__tapvpwrvgnd_1_45 r0 *1 0,0
Xsky130_fd_sc_hd__tapvpwrvgnd_1_45 VSS VDD sky130_fd_sc_hd__tapvpwrvgnd_1
* cell instance sky130_fd_sc_hd__tapvpwrvgnd_1_46 r0 *1 0,0
Xsky130_fd_sc_hd__tapvpwrvgnd_1_46 VSS VDD sky130_fd_sc_hd__tapvpwrvgnd_1
* cell instance sky130_fd_sc_hd__tapvpwrvgnd_1_47 r0 *1 0,0
Xsky130_fd_sc_hd__tapvpwrvgnd_1_47 VSS VDD sky130_fd_sc_hd__tapvpwrvgnd_1
* cell instance sky130_fd_sc_hd__tapvpwrvgnd_1_48 r0 *1 0,0
Xsky130_fd_sc_hd__tapvpwrvgnd_1_48 VSS VDD sky130_fd_sc_hd__tapvpwrvgnd_1
* cell instance sky130_fd_sc_hd__tapvpwrvgnd_1_49 r0 *1 0,0
Xsky130_fd_sc_hd__tapvpwrvgnd_1_49 VSS VDD sky130_fd_sc_hd__tapvpwrvgnd_1
* cell instance sky130_fd_sc_hd__tapvpwrvgnd_1_50 r0 *1 0,0
Xsky130_fd_sc_hd__tapvpwrvgnd_1_50 VSS VDD sky130_fd_sc_hd__tapvpwrvgnd_1
* cell instance sky130_fd_sc_hd__tapvpwrvgnd_1_51 r0 *1 0,0
Xsky130_fd_sc_hd__tapvpwrvgnd_1_51 VSS VDD sky130_fd_sc_hd__tapvpwrvgnd_1
* cell instance sky130_fd_sc_hd__tapvpwrvgnd_1_52 r0 *1 0,0
Xsky130_fd_sc_hd__tapvpwrvgnd_1_52 VSS VDD sky130_fd_sc_hd__tapvpwrvgnd_1
* cell instance sky130_fd_sc_hd__tapvpwrvgnd_1_53 r0 *1 0,0
Xsky130_fd_sc_hd__tapvpwrvgnd_1_53 VSS VDD sky130_fd_sc_hd__tapvpwrvgnd_1
* cell instance sky130_fd_sc_hd__tapvpwrvgnd_1_54 r0 *1 0,0
Xsky130_fd_sc_hd__tapvpwrvgnd_1_54 VSS VDD sky130_fd_sc_hd__tapvpwrvgnd_1
* cell instance sky130_fd_sc_hd__tapvpwrvgnd_1_55 r0 *1 0,0
Xsky130_fd_sc_hd__tapvpwrvgnd_1_55 VSS VDD sky130_fd_sc_hd__tapvpwrvgnd_1
* cell instance sky130_fd_sc_hd__tapvpwrvgnd_1_56 r0 *1 0,0
Xsky130_fd_sc_hd__tapvpwrvgnd_1_56 VSS VDD sky130_fd_sc_hd__tapvpwrvgnd_1
* cell instance sky130_fd_sc_hd__tapvpwrvgnd_1_57 r0 *1 0,0
Xsky130_fd_sc_hd__tapvpwrvgnd_1_57 VSS VDD sky130_fd_sc_hd__tapvpwrvgnd_1
* cell instance sky130_fd_sc_hd__tapvpwrvgnd_1_58 r0 *1 0,0
Xsky130_fd_sc_hd__tapvpwrvgnd_1_58 VSS VDD sky130_fd_sc_hd__tapvpwrvgnd_1
* cell instance sky130_fd_sc_hd__tapvpwrvgnd_1_59 r0 *1 0,0
Xsky130_fd_sc_hd__tapvpwrvgnd_1_59 VSS VDD sky130_fd_sc_hd__tapvpwrvgnd_1
* cell instance sky130_fd_sc_hd__tapvpwrvgnd_1_60 r0 *1 0,0
Xsky130_fd_sc_hd__tapvpwrvgnd_1_60 VSS VDD sky130_fd_sc_hd__tapvpwrvgnd_1
* cell instance sky130_fd_sc_hd__tapvpwrvgnd_1_61 r0 *1 0,0
Xsky130_fd_sc_hd__tapvpwrvgnd_1_61 VSS VDD sky130_fd_sc_hd__tapvpwrvgnd_1
* cell instance sky130_fd_sc_hd__tapvpwrvgnd_1_62 r0 *1 0,0
Xsky130_fd_sc_hd__tapvpwrvgnd_1_62 VSS VDD sky130_fd_sc_hd__tapvpwrvgnd_1
* cell instance sky130_fd_sc_hd__tapvpwrvgnd_1_63 r0 *1 0,0
Xsky130_fd_sc_hd__tapvpwrvgnd_1_63 VSS VDD sky130_fd_sc_hd__tapvpwrvgnd_1
* cell instance sky130_fd_sc_hd__tapvpwrvgnd_1_64 r0 *1 0,0
Xsky130_fd_sc_hd__tapvpwrvgnd_1_64 VSS VDD sky130_fd_sc_hd__tapvpwrvgnd_1
* cell instance sky130_fd_sc_hd__tapvpwrvgnd_1_65 r0 *1 0,0
Xsky130_fd_sc_hd__tapvpwrvgnd_1_65 VSS VDD sky130_fd_sc_hd__tapvpwrvgnd_1
* cell instance sky130_fd_sc_hd__tapvpwrvgnd_1_66 r0 *1 0,0
Xsky130_fd_sc_hd__tapvpwrvgnd_1_66 VSS VDD sky130_fd_sc_hd__tapvpwrvgnd_1
* cell instance sky130_fd_sc_hd__tapvpwrvgnd_1_67 r0 *1 0,0
Xsky130_fd_sc_hd__tapvpwrvgnd_1_67 VSS VDD sky130_fd_sc_hd__tapvpwrvgnd_1
* cell instance sky130_fd_sc_hd__tapvpwrvgnd_1_68 r0 *1 0,0
Xsky130_fd_sc_hd__tapvpwrvgnd_1_68 VSS VDD sky130_fd_sc_hd__tapvpwrvgnd_1
* cell instance sky130_fd_sc_hd__tapvpwrvgnd_1_69 r0 *1 0,0
Xsky130_fd_sc_hd__tapvpwrvgnd_1_69 VSS VDD sky130_fd_sc_hd__tapvpwrvgnd_1
* cell instance sky130_fd_sc_hd__tapvpwrvgnd_1_70 r0 *1 0,0
Xsky130_fd_sc_hd__tapvpwrvgnd_1_70 VSS VDD sky130_fd_sc_hd__tapvpwrvgnd_1
* cell instance sky130_fd_sc_hd__tapvpwrvgnd_1_71 r0 *1 0,0
Xsky130_fd_sc_hd__tapvpwrvgnd_1_71 VSS VDD sky130_fd_sc_hd__tapvpwrvgnd_1
* cell instance sky130_fd_sc_hd__tapvpwrvgnd_1_72 r0 *1 0,0
Xsky130_fd_sc_hd__tapvpwrvgnd_1_72 VSS VDD sky130_fd_sc_hd__tapvpwrvgnd_1
* cell instance sky130_fd_sc_hd__tapvpwrvgnd_1_73 r0 *1 0,0
Xsky130_fd_sc_hd__tapvpwrvgnd_1_73 VSS VDD sky130_fd_sc_hd__tapvpwrvgnd_1
* cell instance sky130_fd_sc_hd__tapvpwrvgnd_1_74 r0 *1 0,0
Xsky130_fd_sc_hd__tapvpwrvgnd_1_74 VSS VDD sky130_fd_sc_hd__tapvpwrvgnd_1
* cell instance sky130_fd_sc_hd__tapvpwrvgnd_1_75 r0 *1 0,0
Xsky130_fd_sc_hd__tapvpwrvgnd_1_75 VSS VDD sky130_fd_sc_hd__tapvpwrvgnd_1
* cell instance sky130_fd_sc_hd__tapvpwrvgnd_1_76 r0 *1 0,0
Xsky130_fd_sc_hd__tapvpwrvgnd_1_76 VSS VDD sky130_fd_sc_hd__tapvpwrvgnd_1
* cell instance sky130_fd_sc_hd__tapvpwrvgnd_1_77 r0 *1 0,0
Xsky130_fd_sc_hd__tapvpwrvgnd_1_77 VSS VDD sky130_fd_sc_hd__tapvpwrvgnd_1
* cell instance sky130_fd_sc_hd__tapvpwrvgnd_1_78 r0 *1 0,0
Xsky130_fd_sc_hd__tapvpwrvgnd_1_78 VSS VDD sky130_fd_sc_hd__tapvpwrvgnd_1
* cell instance sky130_fd_sc_hd__tapvpwrvgnd_1_79 r0 *1 0,0
Xsky130_fd_sc_hd__tapvpwrvgnd_1_79 VSS VDD sky130_fd_sc_hd__tapvpwrvgnd_1
* cell instance sky130_fd_sc_hd__tapvpwrvgnd_1_80 r0 *1 0,0
Xsky130_fd_sc_hd__tapvpwrvgnd_1_80 VSS VDD sky130_fd_sc_hd__tapvpwrvgnd_1
* cell instance sky130_fd_sc_hd__tapvpwrvgnd_1_81 r0 *1 0,0
Xsky130_fd_sc_hd__tapvpwrvgnd_1_81 VSS VDD sky130_fd_sc_hd__tapvpwrvgnd_1
* cell instance sky130_fd_sc_hd__tapvpwrvgnd_1_82 r0 *1 0,0
Xsky130_fd_sc_hd__tapvpwrvgnd_1_82 VSS VDD sky130_fd_sc_hd__tapvpwrvgnd_1
* cell instance sky130_fd_sc_hd__tapvpwrvgnd_1_83 r0 *1 0,0
Xsky130_fd_sc_hd__tapvpwrvgnd_1_83 VSS VDD sky130_fd_sc_hd__tapvpwrvgnd_1
* cell instance sky130_fd_sc_hd__tapvpwrvgnd_1_84 r0 *1 0,0
Xsky130_fd_sc_hd__tapvpwrvgnd_1_84 VSS VDD sky130_fd_sc_hd__tapvpwrvgnd_1
* cell instance sky130_fd_sc_hd__tapvpwrvgnd_1_85 r0 *1 0,0
Xsky130_fd_sc_hd__tapvpwrvgnd_1_85 VSS VDD sky130_fd_sc_hd__tapvpwrvgnd_1
* cell instance sky130_fd_sc_hd__tapvpwrvgnd_1_86 r0 *1 0,0
Xsky130_fd_sc_hd__tapvpwrvgnd_1_86 VSS VDD sky130_fd_sc_hd__tapvpwrvgnd_1
* cell instance sky130_fd_sc_hd__tapvpwrvgnd_1_87 r0 *1 0,0
Xsky130_fd_sc_hd__tapvpwrvgnd_1_87 VSS VDD sky130_fd_sc_hd__tapvpwrvgnd_1
* cell instance sky130_fd_sc_hd__tapvpwrvgnd_1_88 r0 *1 0,0
Xsky130_fd_sc_hd__tapvpwrvgnd_1_88 VSS VDD sky130_fd_sc_hd__tapvpwrvgnd_1
* cell instance sky130_fd_sc_hd__tapvpwrvgnd_1_89 r0 *1 0,0
Xsky130_fd_sc_hd__tapvpwrvgnd_1_89 VSS VDD sky130_fd_sc_hd__tapvpwrvgnd_1
* cell instance sky130_fd_sc_hd__tapvpwrvgnd_1_90 r0 *1 0,0
Xsky130_fd_sc_hd__tapvpwrvgnd_1_90 VSS VDD sky130_fd_sc_hd__tapvpwrvgnd_1
* cell instance sky130_fd_sc_hd__tapvpwrvgnd_1_91 r0 *1 0,0
Xsky130_fd_sc_hd__tapvpwrvgnd_1_91 VSS VDD sky130_fd_sc_hd__tapvpwrvgnd_1
* cell instance sky130_fd_sc_hd__tapvpwrvgnd_1_92 r0 *1 0,0
Xsky130_fd_sc_hd__tapvpwrvgnd_1_92 VSS VDD sky130_fd_sc_hd__tapvpwrvgnd_1
* cell instance sky130_fd_sc_hd__tapvpwrvgnd_1_93 r0 *1 0,0
Xsky130_fd_sc_hd__tapvpwrvgnd_1_93 VSS VDD sky130_fd_sc_hd__tapvpwrvgnd_1
* cell instance sky130_fd_sc_hd__tapvpwrvgnd_1_94 r0 *1 0,0
Xsky130_fd_sc_hd__tapvpwrvgnd_1_94 VSS VDD sky130_fd_sc_hd__tapvpwrvgnd_1
* cell instance sky130_fd_sc_hd__tapvpwrvgnd_1_95 r0 *1 0,0
Xsky130_fd_sc_hd__tapvpwrvgnd_1_95 VSS VDD sky130_fd_sc_hd__tapvpwrvgnd_1
* cell instance sky130_fd_sc_hd__tapvpwrvgnd_1_96 r0 *1 0,0
Xsky130_fd_sc_hd__tapvpwrvgnd_1_96 VSS VDD sky130_fd_sc_hd__tapvpwrvgnd_1
* cell instance sky130_fd_sc_hd__tapvpwrvgnd_1_97 r0 *1 0,0
Xsky130_fd_sc_hd__tapvpwrvgnd_1_97 VSS VDD sky130_fd_sc_hd__tapvpwrvgnd_1
* cell instance sky130_fd_sc_hd__tapvpwrvgnd_1_98 r0 *1 0,0
Xsky130_fd_sc_hd__tapvpwrvgnd_1_98 VSS VDD sky130_fd_sc_hd__tapvpwrvgnd_1
* cell instance sky130_fd_sc_hd__tapvpwrvgnd_1_99 r0 *1 0,0
Xsky130_fd_sc_hd__tapvpwrvgnd_1_99 VSS VDD sky130_fd_sc_hd__tapvpwrvgnd_1
* cell instance sky130_fd_sc_hd__tapvpwrvgnd_1_100 r0 *1 0,0
Xsky130_fd_sc_hd__tapvpwrvgnd_1_100 VSS VDD sky130_fd_sc_hd__tapvpwrvgnd_1
* cell instance sky130_fd_sc_hd__tapvpwrvgnd_1_101 r0 *1 0,0
Xsky130_fd_sc_hd__tapvpwrvgnd_1_101 VSS VDD sky130_fd_sc_hd__tapvpwrvgnd_1
* cell instance sky130_fd_sc_hd__tapvpwrvgnd_1_102 r0 *1 0,0
Xsky130_fd_sc_hd__tapvpwrvgnd_1_102 VSS VDD sky130_fd_sc_hd__tapvpwrvgnd_1
* cell instance sky130_fd_sc_hd__tapvpwrvgnd_1_103 r0 *1 0,0
Xsky130_fd_sc_hd__tapvpwrvgnd_1_103 VSS VDD sky130_fd_sc_hd__tapvpwrvgnd_1
* cell instance sky130_fd_sc_hd__tapvpwrvgnd_1_104 r0 *1 0,0
Xsky130_fd_sc_hd__tapvpwrvgnd_1_104 VSS VDD sky130_fd_sc_hd__tapvpwrvgnd_1
* cell instance sky130_fd_sc_hd__tapvpwrvgnd_1_105 r0 *1 0,0
Xsky130_fd_sc_hd__tapvpwrvgnd_1_105 VSS VDD sky130_fd_sc_hd__tapvpwrvgnd_1
* cell instance sky130_fd_sc_hd__tapvpwrvgnd_1_106 r0 *1 0,0
Xsky130_fd_sc_hd__tapvpwrvgnd_1_106 VSS VDD sky130_fd_sc_hd__tapvpwrvgnd_1
* cell instance sky130_fd_sc_hd__tapvpwrvgnd_1_107 r0 *1 0,0
Xsky130_fd_sc_hd__tapvpwrvgnd_1_107 VSS VDD sky130_fd_sc_hd__tapvpwrvgnd_1
* cell instance sky130_fd_sc_hd__tapvpwrvgnd_1_108 r0 *1 0,0
Xsky130_fd_sc_hd__tapvpwrvgnd_1_108 VSS VDD sky130_fd_sc_hd__tapvpwrvgnd_1
* cell instance sky130_fd_sc_hd__tapvpwrvgnd_1_109 r0 *1 0,0
Xsky130_fd_sc_hd__tapvpwrvgnd_1_109 VSS VDD sky130_fd_sc_hd__tapvpwrvgnd_1
* cell instance sky130_fd_sc_hd__tapvpwrvgnd_1_110 r0 *1 0,0
Xsky130_fd_sc_hd__tapvpwrvgnd_1_110 VSS VDD sky130_fd_sc_hd__tapvpwrvgnd_1
* cell instance sky130_fd_sc_hd__tapvpwrvgnd_1_111 r0 *1 0,0
Xsky130_fd_sc_hd__tapvpwrvgnd_1_111 VSS VDD sky130_fd_sc_hd__tapvpwrvgnd_1
* cell instance sky130_fd_sc_hd__tapvpwrvgnd_1_112 r0 *1 0,0
Xsky130_fd_sc_hd__tapvpwrvgnd_1_112 VSS VDD sky130_fd_sc_hd__tapvpwrvgnd_1
* cell instance sky130_fd_sc_hd__tapvpwrvgnd_1_113 r0 *1 0,0
Xsky130_fd_sc_hd__tapvpwrvgnd_1_113 VSS VDD sky130_fd_sc_hd__tapvpwrvgnd_1
* cell instance sky130_fd_sc_hd__tapvpwrvgnd_1_114 r0 *1 0,0
Xsky130_fd_sc_hd__tapvpwrvgnd_1_114 VSS VDD sky130_fd_sc_hd__tapvpwrvgnd_1
* cell instance sky130_fd_sc_hd__tapvpwrvgnd_1_115 r0 *1 0,0
Xsky130_fd_sc_hd__tapvpwrvgnd_1_115 VSS VDD sky130_fd_sc_hd__tapvpwrvgnd_1
* cell instance sky130_fd_sc_hd__tapvpwrvgnd_1_116 r0 *1 0,0
Xsky130_fd_sc_hd__tapvpwrvgnd_1_116 VSS VDD sky130_fd_sc_hd__tapvpwrvgnd_1
* cell instance sky130_fd_sc_hd__tapvpwrvgnd_1_117 r0 *1 0,0
Xsky130_fd_sc_hd__tapvpwrvgnd_1_117 VSS VDD sky130_fd_sc_hd__tapvpwrvgnd_1
* cell instance sky130_fd_sc_hd__tapvpwrvgnd_1_118 r0 *1 0,0
Xsky130_fd_sc_hd__tapvpwrvgnd_1_118 VSS VDD sky130_fd_sc_hd__tapvpwrvgnd_1
* cell instance sky130_fd_sc_hd__tapvpwrvgnd_1_119 r0 *1 0,0
Xsky130_fd_sc_hd__tapvpwrvgnd_1_119 VSS VDD sky130_fd_sc_hd__tapvpwrvgnd_1
* cell instance sky130_fd_sc_hd__tapvpwrvgnd_1_120 r0 *1 0,0
Xsky130_fd_sc_hd__tapvpwrvgnd_1_120 VSS VDD sky130_fd_sc_hd__tapvpwrvgnd_1
* cell instance sky130_fd_sc_hd__tapvpwrvgnd_1_121 r0 *1 0,0
Xsky130_fd_sc_hd__tapvpwrvgnd_1_121 VSS VDD sky130_fd_sc_hd__tapvpwrvgnd_1
* cell instance sky130_fd_sc_hd__tapvpwrvgnd_1_122 r0 *1 0,0
Xsky130_fd_sc_hd__tapvpwrvgnd_1_122 VSS VDD sky130_fd_sc_hd__tapvpwrvgnd_1
* cell instance sky130_fd_sc_hd__tapvpwrvgnd_1_123 r0 *1 0,0
Xsky130_fd_sc_hd__tapvpwrvgnd_1_123 VSS VDD sky130_fd_sc_hd__tapvpwrvgnd_1
* cell instance sky130_fd_sc_hd__tapvpwrvgnd_1_124 r0 *1 0,0
Xsky130_fd_sc_hd__tapvpwrvgnd_1_124 VSS VDD sky130_fd_sc_hd__tapvpwrvgnd_1
* cell instance sky130_fd_sc_hd__tapvpwrvgnd_1_125 r0 *1 0,0
Xsky130_fd_sc_hd__tapvpwrvgnd_1_125 VSS VDD sky130_fd_sc_hd__tapvpwrvgnd_1
* cell instance sky130_fd_sc_hd__tapvpwrvgnd_1_126 r0 *1 0,0
Xsky130_fd_sc_hd__tapvpwrvgnd_1_126 VSS VDD sky130_fd_sc_hd__tapvpwrvgnd_1
* cell instance sky130_fd_sc_hd__tapvpwrvgnd_1_127 r0 *1 0,0
Xsky130_fd_sc_hd__tapvpwrvgnd_1_127 VSS VDD sky130_fd_sc_hd__tapvpwrvgnd_1
* cell instance sky130_fd_sc_hd__tapvpwrvgnd_1_128 r0 *1 0,0
Xsky130_fd_sc_hd__tapvpwrvgnd_1_128 VSS VDD sky130_fd_sc_hd__tapvpwrvgnd_1
* cell instance sky130_fd_sc_hd__tapvpwrvgnd_1_129 r0 *1 0,0
Xsky130_fd_sc_hd__tapvpwrvgnd_1_129 VSS VDD sky130_fd_sc_hd__tapvpwrvgnd_1
* cell instance sky130_fd_sc_hd__tapvpwrvgnd_1_130 r0 *1 0,0
Xsky130_fd_sc_hd__tapvpwrvgnd_1_130 VSS VDD sky130_fd_sc_hd__tapvpwrvgnd_1
* cell instance sky130_fd_sc_hd__tapvpwrvgnd_1_131 r0 *1 0,0
Xsky130_fd_sc_hd__tapvpwrvgnd_1_131 VSS VDD sky130_fd_sc_hd__tapvpwrvgnd_1
* cell instance sky130_fd_sc_hd__tapvpwrvgnd_1_132 r0 *1 0,0
Xsky130_fd_sc_hd__tapvpwrvgnd_1_132 VSS VDD sky130_fd_sc_hd__tapvpwrvgnd_1
* cell instance sky130_fd_sc_hd__tapvpwrvgnd_1_133 r0 *1 0,0
Xsky130_fd_sc_hd__tapvpwrvgnd_1_133 VSS VDD sky130_fd_sc_hd__tapvpwrvgnd_1
* cell instance sky130_fd_sc_hd__tapvpwrvgnd_1_134 r0 *1 0,0
Xsky130_fd_sc_hd__tapvpwrvgnd_1_134 VSS VDD sky130_fd_sc_hd__tapvpwrvgnd_1
* cell instance sky130_fd_sc_hd__tapvpwrvgnd_1_135 r0 *1 0,0
Xsky130_fd_sc_hd__tapvpwrvgnd_1_135 VSS VDD sky130_fd_sc_hd__tapvpwrvgnd_1
* cell instance sky130_fd_sc_hd__tapvpwrvgnd_1_136 r0 *1 0,0
Xsky130_fd_sc_hd__tapvpwrvgnd_1_136 VSS VDD sky130_fd_sc_hd__tapvpwrvgnd_1
* cell instance sky130_fd_sc_hd__tapvpwrvgnd_1_137 r0 *1 0,0
Xsky130_fd_sc_hd__tapvpwrvgnd_1_137 VSS VDD sky130_fd_sc_hd__tapvpwrvgnd_1
* cell instance sky130_fd_sc_hd__tapvpwrvgnd_1_138 r0 *1 0,0
Xsky130_fd_sc_hd__tapvpwrvgnd_1_138 VSS VDD sky130_fd_sc_hd__tapvpwrvgnd_1
* cell instance sky130_fd_sc_hd__tapvpwrvgnd_1_139 r0 *1 0,0
Xsky130_fd_sc_hd__tapvpwrvgnd_1_139 VSS VDD sky130_fd_sc_hd__tapvpwrvgnd_1
* cell instance sky130_fd_sc_hd__tapvpwrvgnd_1_140 r0 *1 0,0
Xsky130_fd_sc_hd__tapvpwrvgnd_1_140 VSS VDD sky130_fd_sc_hd__tapvpwrvgnd_1
* cell instance sky130_fd_sc_hd__tapvpwrvgnd_1_141 r0 *1 0,0
Xsky130_fd_sc_hd__tapvpwrvgnd_1_141 VSS VDD sky130_fd_sc_hd__tapvpwrvgnd_1
* cell instance sky130_fd_sc_hd__tapvpwrvgnd_1_142 r0 *1 0,0
Xsky130_fd_sc_hd__tapvpwrvgnd_1_142 VSS VDD sky130_fd_sc_hd__tapvpwrvgnd_1
* cell instance sky130_fd_sc_hd__tapvpwrvgnd_1_143 r0 *1 0,0
Xsky130_fd_sc_hd__tapvpwrvgnd_1_143 VSS VDD sky130_fd_sc_hd__tapvpwrvgnd_1
* cell instance sky130_fd_sc_hd__tapvpwrvgnd_1_144 r0 *1 0,0
Xsky130_fd_sc_hd__tapvpwrvgnd_1_144 VSS VDD sky130_fd_sc_hd__tapvpwrvgnd_1
* cell instance sky130_fd_sc_hd__tapvpwrvgnd_1_145 r0 *1 0,0
Xsky130_fd_sc_hd__tapvpwrvgnd_1_145 VSS VDD sky130_fd_sc_hd__tapvpwrvgnd_1
* cell instance sky130_fd_sc_hd__tapvpwrvgnd_1_146 r0 *1 0,0
Xsky130_fd_sc_hd__tapvpwrvgnd_1_146 VSS VDD sky130_fd_sc_hd__tapvpwrvgnd_1
* cell instance sky130_fd_sc_hd__tapvpwrvgnd_1_147 r0 *1 0,0
Xsky130_fd_sc_hd__tapvpwrvgnd_1_147 VSS VDD sky130_fd_sc_hd__tapvpwrvgnd_1
* cell instance sky130_fd_sc_hd__tapvpwrvgnd_1_148 r0 *1 0,0
Xsky130_fd_sc_hd__tapvpwrvgnd_1_148 VSS VDD sky130_fd_sc_hd__tapvpwrvgnd_1
* cell instance sky130_fd_sc_hd__tapvpwrvgnd_1_149 r0 *1 0,0
Xsky130_fd_sc_hd__tapvpwrvgnd_1_149 VSS VDD sky130_fd_sc_hd__tapvpwrvgnd_1
* cell instance sky130_fd_sc_hd__tapvpwrvgnd_1_150 r0 *1 0,0
Xsky130_fd_sc_hd__tapvpwrvgnd_1_150 VSS VDD sky130_fd_sc_hd__tapvpwrvgnd_1
* cell instance sky130_fd_sc_hd__tapvpwrvgnd_1_151 r0 *1 0,0
Xsky130_fd_sc_hd__tapvpwrvgnd_1_151 VSS VDD sky130_fd_sc_hd__tapvpwrvgnd_1
* cell instance sky130_fd_sc_hd__tapvpwrvgnd_1_152 r0 *1 0,0
Xsky130_fd_sc_hd__tapvpwrvgnd_1_152 VSS VDD sky130_fd_sc_hd__tapvpwrvgnd_1
* cell instance sky130_fd_sc_hd__tapvpwrvgnd_1_153 r0 *1 0,0
Xsky130_fd_sc_hd__tapvpwrvgnd_1_153 VSS VDD sky130_fd_sc_hd__tapvpwrvgnd_1
* cell instance sky130_fd_sc_hd__tapvpwrvgnd_1_154 r0 *1 0,0
Xsky130_fd_sc_hd__tapvpwrvgnd_1_154 VSS VDD sky130_fd_sc_hd__tapvpwrvgnd_1
* cell instance sky130_fd_sc_hd__tapvpwrvgnd_1_155 r0 *1 0,0
Xsky130_fd_sc_hd__tapvpwrvgnd_1_155 VSS VDD sky130_fd_sc_hd__tapvpwrvgnd_1
* cell instance sky130_fd_sc_hd__tapvpwrvgnd_1_156 r0 *1 0,0
Xsky130_fd_sc_hd__tapvpwrvgnd_1_156 VSS VDD sky130_fd_sc_hd__tapvpwrvgnd_1
* cell instance sky130_fd_sc_hd__tapvpwrvgnd_1_157 r0 *1 0,0
Xsky130_fd_sc_hd__tapvpwrvgnd_1_157 VSS VDD sky130_fd_sc_hd__tapvpwrvgnd_1
* cell instance sky130_fd_sc_hd__tapvpwrvgnd_1_158 r0 *1 0,0
Xsky130_fd_sc_hd__tapvpwrvgnd_1_158 VSS VDD sky130_fd_sc_hd__tapvpwrvgnd_1
* cell instance sky130_fd_sc_hd__tapvpwrvgnd_1_159 r0 *1 0,0
Xsky130_fd_sc_hd__tapvpwrvgnd_1_159 VSS VDD sky130_fd_sc_hd__tapvpwrvgnd_1
* cell instance sky130_fd_sc_hd__tapvpwrvgnd_1_160 r0 *1 0,0
Xsky130_fd_sc_hd__tapvpwrvgnd_1_160 VSS VDD sky130_fd_sc_hd__tapvpwrvgnd_1
* cell instance sky130_fd_sc_hd__tapvpwrvgnd_1_161 r0 *1 0,0
Xsky130_fd_sc_hd__tapvpwrvgnd_1_161 VSS VDD sky130_fd_sc_hd__tapvpwrvgnd_1
* cell instance sky130_fd_sc_hd__tapvpwrvgnd_1_162 r0 *1 0,0
Xsky130_fd_sc_hd__tapvpwrvgnd_1_162 VSS VDD sky130_fd_sc_hd__tapvpwrvgnd_1
* cell instance sky130_fd_sc_hd__tapvpwrvgnd_1_163 r0 *1 0,0
Xsky130_fd_sc_hd__tapvpwrvgnd_1_163 VSS VDD sky130_fd_sc_hd__tapvpwrvgnd_1
* cell instance sky130_fd_sc_hd__tapvpwrvgnd_1_164 r0 *1 0,0
Xsky130_fd_sc_hd__tapvpwrvgnd_1_164 VSS VDD sky130_fd_sc_hd__tapvpwrvgnd_1
* cell instance sky130_fd_sc_hd__tapvpwrvgnd_1_165 r0 *1 0,0
Xsky130_fd_sc_hd__tapvpwrvgnd_1_165 VSS VDD sky130_fd_sc_hd__tapvpwrvgnd_1
* cell instance sky130_fd_sc_hd__tapvpwrvgnd_1_166 r0 *1 0,0
Xsky130_fd_sc_hd__tapvpwrvgnd_1_166 VSS VDD sky130_fd_sc_hd__tapvpwrvgnd_1
* cell instance sky130_fd_sc_hd__tapvpwrvgnd_1_167 r0 *1 0,0
Xsky130_fd_sc_hd__tapvpwrvgnd_1_167 VSS VDD sky130_fd_sc_hd__tapvpwrvgnd_1
* cell instance sky130_fd_sc_hd__tapvpwrvgnd_1_168 r0 *1 0,0
Xsky130_fd_sc_hd__tapvpwrvgnd_1_168 VSS VDD sky130_fd_sc_hd__tapvpwrvgnd_1
* cell instance sky130_fd_sc_hd__tapvpwrvgnd_1_169 r0 *1 0,0
Xsky130_fd_sc_hd__tapvpwrvgnd_1_169 VSS VDD sky130_fd_sc_hd__tapvpwrvgnd_1
* cell instance sky130_fd_sc_hd__tapvpwrvgnd_1_170 r0 *1 0,0
Xsky130_fd_sc_hd__tapvpwrvgnd_1_170 VSS VDD sky130_fd_sc_hd__tapvpwrvgnd_1
* cell instance sky130_fd_sc_hd__tapvpwrvgnd_1_171 r0 *1 0,0
Xsky130_fd_sc_hd__tapvpwrvgnd_1_171 VSS VDD sky130_fd_sc_hd__tapvpwrvgnd_1
* cell instance sky130_fd_sc_hd__tapvpwrvgnd_1_172 r0 *1 0,0
Xsky130_fd_sc_hd__tapvpwrvgnd_1_172 VSS VDD sky130_fd_sc_hd__tapvpwrvgnd_1
* cell instance sky130_fd_sc_hd__tapvpwrvgnd_1_173 r0 *1 0,0
Xsky130_fd_sc_hd__tapvpwrvgnd_1_173 VSS VDD sky130_fd_sc_hd__tapvpwrvgnd_1
* cell instance sky130_fd_sc_hd__tapvpwrvgnd_1_174 r0 *1 0,0
Xsky130_fd_sc_hd__tapvpwrvgnd_1_174 VSS VDD sky130_fd_sc_hd__tapvpwrvgnd_1
* cell instance sky130_fd_sc_hd__tapvpwrvgnd_1_175 r0 *1 0,0
Xsky130_fd_sc_hd__tapvpwrvgnd_1_175 VSS VDD sky130_fd_sc_hd__tapvpwrvgnd_1
* cell instance sky130_fd_sc_hd__tapvpwrvgnd_1_176 r0 *1 0,0
Xsky130_fd_sc_hd__tapvpwrvgnd_1_176 VSS VDD sky130_fd_sc_hd__tapvpwrvgnd_1
* cell instance sky130_fd_sc_hd__tapvpwrvgnd_1_177 r0 *1 0,0
Xsky130_fd_sc_hd__tapvpwrvgnd_1_177 VSS VDD sky130_fd_sc_hd__tapvpwrvgnd_1
* cell instance sky130_fd_sc_hd__tapvpwrvgnd_1_178 r0 *1 0,0
Xsky130_fd_sc_hd__tapvpwrvgnd_1_178 VSS VDD sky130_fd_sc_hd__tapvpwrvgnd_1
* cell instance sky130_fd_sc_hd__tapvpwrvgnd_1_179 r0 *1 0,0
Xsky130_fd_sc_hd__tapvpwrvgnd_1_179 VSS VDD sky130_fd_sc_hd__tapvpwrvgnd_1
* cell instance sky130_fd_sc_hd__tapvpwrvgnd_1_180 r0 *1 0,0
Xsky130_fd_sc_hd__tapvpwrvgnd_1_180 VSS VDD sky130_fd_sc_hd__tapvpwrvgnd_1
* cell instance sky130_fd_sc_hd__tapvpwrvgnd_1_181 r0 *1 0,0
Xsky130_fd_sc_hd__tapvpwrvgnd_1_181 VSS VDD sky130_fd_sc_hd__tapvpwrvgnd_1
* cell instance sky130_fd_sc_hd__tapvpwrvgnd_1_182 r0 *1 0,0
Xsky130_fd_sc_hd__tapvpwrvgnd_1_182 VSS VDD sky130_fd_sc_hd__tapvpwrvgnd_1
* cell instance sky130_fd_sc_hd__tapvpwrvgnd_1_183 r0 *1 0,0
Xsky130_fd_sc_hd__tapvpwrvgnd_1_183 VSS VDD sky130_fd_sc_hd__tapvpwrvgnd_1
* cell instance sky130_fd_sc_hd__tapvpwrvgnd_1_184 r0 *1 0,0
Xsky130_fd_sc_hd__tapvpwrvgnd_1_184 VSS VDD sky130_fd_sc_hd__tapvpwrvgnd_1
* cell instance sky130_fd_sc_hd__tapvpwrvgnd_1_185 r0 *1 0,0
Xsky130_fd_sc_hd__tapvpwrvgnd_1_185 VSS VDD sky130_fd_sc_hd__tapvpwrvgnd_1
* cell instance sky130_fd_sc_hd__tapvpwrvgnd_1_186 r0 *1 0,0
Xsky130_fd_sc_hd__tapvpwrvgnd_1_186 VSS VDD sky130_fd_sc_hd__tapvpwrvgnd_1
* cell instance sky130_fd_sc_hd__tapvpwrvgnd_1_187 r0 *1 0,0
Xsky130_fd_sc_hd__tapvpwrvgnd_1_187 VSS VDD sky130_fd_sc_hd__tapvpwrvgnd_1
* cell instance sky130_fd_sc_hd__tapvpwrvgnd_1_188 r0 *1 0,0
Xsky130_fd_sc_hd__tapvpwrvgnd_1_188 VSS VDD sky130_fd_sc_hd__tapvpwrvgnd_1
* cell instance sky130_fd_sc_hd__tapvpwrvgnd_1_189 r0 *1 0,0
Xsky130_fd_sc_hd__tapvpwrvgnd_1_189 VSS VDD sky130_fd_sc_hd__tapvpwrvgnd_1
* cell instance sky130_fd_sc_hd__tapvpwrvgnd_1_190 r0 *1 0,0
Xsky130_fd_sc_hd__tapvpwrvgnd_1_190 VSS VDD sky130_fd_sc_hd__tapvpwrvgnd_1
* cell instance sky130_fd_sc_hd__tapvpwrvgnd_1_191 r0 *1 0,0
Xsky130_fd_sc_hd__tapvpwrvgnd_1_191 VSS VDD sky130_fd_sc_hd__tapvpwrvgnd_1
* cell instance sky130_fd_sc_hd__tapvpwrvgnd_1_192 r0 *1 0,0
Xsky130_fd_sc_hd__tapvpwrvgnd_1_192 VSS VDD sky130_fd_sc_hd__tapvpwrvgnd_1
* cell instance sky130_fd_sc_hd__tapvpwrvgnd_1_193 r0 *1 0,0
Xsky130_fd_sc_hd__tapvpwrvgnd_1_193 VSS VDD sky130_fd_sc_hd__tapvpwrvgnd_1
* cell instance sky130_fd_sc_hd__tapvpwrvgnd_1_194 r0 *1 0,0
Xsky130_fd_sc_hd__tapvpwrvgnd_1_194 VSS VDD sky130_fd_sc_hd__tapvpwrvgnd_1
* cell instance sky130_fd_sc_hd__tapvpwrvgnd_1_195 r0 *1 0,0
Xsky130_fd_sc_hd__tapvpwrvgnd_1_195 VSS VDD sky130_fd_sc_hd__tapvpwrvgnd_1
* cell instance sky130_fd_sc_hd__tapvpwrvgnd_1_196 r0 *1 0,0
Xsky130_fd_sc_hd__tapvpwrvgnd_1_196 VSS VDD sky130_fd_sc_hd__tapvpwrvgnd_1
* cell instance sky130_fd_sc_hd__tapvpwrvgnd_1_197 r0 *1 0,0
Xsky130_fd_sc_hd__tapvpwrvgnd_1_197 VSS VDD sky130_fd_sc_hd__tapvpwrvgnd_1
* cell instance sky130_fd_sc_hd__tapvpwrvgnd_1_198 r0 *1 0,0
Xsky130_fd_sc_hd__tapvpwrvgnd_1_198 VSS VDD sky130_fd_sc_hd__tapvpwrvgnd_1
* cell instance sky130_fd_sc_hd__tapvpwrvgnd_1_199 r0 *1 0,0
Xsky130_fd_sc_hd__tapvpwrvgnd_1_199 VSS VDD sky130_fd_sc_hd__tapvpwrvgnd_1
* cell instance sky130_fd_sc_hd__tapvpwrvgnd_1_200 r0 *1 0,0
Xsky130_fd_sc_hd__tapvpwrvgnd_1_200 VSS VDD sky130_fd_sc_hd__tapvpwrvgnd_1
* cell instance sky130_fd_sc_hd__tapvpwrvgnd_1_201 r0 *1 0,0
Xsky130_fd_sc_hd__tapvpwrvgnd_1_201 VSS VDD sky130_fd_sc_hd__tapvpwrvgnd_1
* cell instance sky130_fd_sc_hd__tapvpwrvgnd_1_202 r0 *1 0,0
Xsky130_fd_sc_hd__tapvpwrvgnd_1_202 VSS VDD sky130_fd_sc_hd__tapvpwrvgnd_1
* cell instance sky130_fd_sc_hd__tapvpwrvgnd_1_203 r0 *1 0,0
Xsky130_fd_sc_hd__tapvpwrvgnd_1_203 VSS VDD sky130_fd_sc_hd__tapvpwrvgnd_1
* cell instance sky130_fd_sc_hd__tapvpwrvgnd_1_204 r0 *1 0,0
Xsky130_fd_sc_hd__tapvpwrvgnd_1_204 VSS VDD sky130_fd_sc_hd__tapvpwrvgnd_1
* cell instance sky130_fd_sc_hd__tapvpwrvgnd_1_205 r0 *1 0,0
Xsky130_fd_sc_hd__tapvpwrvgnd_1_205 VSS VDD sky130_fd_sc_hd__tapvpwrvgnd_1
* cell instance sky130_fd_sc_hd__tapvpwrvgnd_1_206 r0 *1 0,0
Xsky130_fd_sc_hd__tapvpwrvgnd_1_206 VSS VDD sky130_fd_sc_hd__tapvpwrvgnd_1
* cell instance sky130_fd_sc_hd__tapvpwrvgnd_1_207 r0 *1 0,0
Xsky130_fd_sc_hd__tapvpwrvgnd_1_207 VSS VDD sky130_fd_sc_hd__tapvpwrvgnd_1
* cell instance sky130_fd_sc_hd__tapvpwrvgnd_1_208 r0 *1 0,0
Xsky130_fd_sc_hd__tapvpwrvgnd_1_208 VSS VDD sky130_fd_sc_hd__tapvpwrvgnd_1
* cell instance sky130_fd_sc_hd__tapvpwrvgnd_1_209 r0 *1 0,0
Xsky130_fd_sc_hd__tapvpwrvgnd_1_209 VSS VDD sky130_fd_sc_hd__tapvpwrvgnd_1
* cell instance sky130_fd_sc_hd__tapvpwrvgnd_1_210 r0 *1 0,0
Xsky130_fd_sc_hd__tapvpwrvgnd_1_210 VSS VDD sky130_fd_sc_hd__tapvpwrvgnd_1
* cell instance sky130_fd_sc_hd__tapvpwrvgnd_1_211 r0 *1 0,0
Xsky130_fd_sc_hd__tapvpwrvgnd_1_211 VSS VDD sky130_fd_sc_hd__tapvpwrvgnd_1
* cell instance sky130_fd_sc_hd__tapvpwrvgnd_1_212 r0 *1 0,0
Xsky130_fd_sc_hd__tapvpwrvgnd_1_212 VSS VDD sky130_fd_sc_hd__tapvpwrvgnd_1
* cell instance sky130_fd_sc_hd__tapvpwrvgnd_1_213 r0 *1 0,0
Xsky130_fd_sc_hd__tapvpwrvgnd_1_213 VSS VDD sky130_fd_sc_hd__tapvpwrvgnd_1
* cell instance sky130_fd_sc_hd__tapvpwrvgnd_1_214 r0 *1 0,0
Xsky130_fd_sc_hd__tapvpwrvgnd_1_214 VSS VDD sky130_fd_sc_hd__tapvpwrvgnd_1
* cell instance sky130_fd_sc_hd__tapvpwrvgnd_1_215 r0 *1 0,0
Xsky130_fd_sc_hd__tapvpwrvgnd_1_215 VSS VDD sky130_fd_sc_hd__tapvpwrvgnd_1
* cell instance sky130_fd_sc_hd__tapvpwrvgnd_1_216 r0 *1 0,0
Xsky130_fd_sc_hd__tapvpwrvgnd_1_216 VSS VDD sky130_fd_sc_hd__tapvpwrvgnd_1
* cell instance sky130_fd_sc_hd__tapvpwrvgnd_1_217 r0 *1 0,0
Xsky130_fd_sc_hd__tapvpwrvgnd_1_217 VSS VDD sky130_fd_sc_hd__tapvpwrvgnd_1
* cell instance sky130_fd_sc_hd__tapvpwrvgnd_1_218 r0 *1 0,0
Xsky130_fd_sc_hd__tapvpwrvgnd_1_218 VSS VDD sky130_fd_sc_hd__tapvpwrvgnd_1
* cell instance sky130_fd_sc_hd__tapvpwrvgnd_1_219 r0 *1 0,0
Xsky130_fd_sc_hd__tapvpwrvgnd_1_219 VSS VDD sky130_fd_sc_hd__tapvpwrvgnd_1
* cell instance sky130_fd_sc_hd__tapvpwrvgnd_1_220 r0 *1 0,0
Xsky130_fd_sc_hd__tapvpwrvgnd_1_220 VSS VDD sky130_fd_sc_hd__tapvpwrvgnd_1
* cell instance sky130_fd_sc_hd__tapvpwrvgnd_1_221 r0 *1 0,0
Xsky130_fd_sc_hd__tapvpwrvgnd_1_221 VSS VDD sky130_fd_sc_hd__tapvpwrvgnd_1
* cell instance sky130_fd_sc_hd__tapvpwrvgnd_1_222 r0 *1 0,0
Xsky130_fd_sc_hd__tapvpwrvgnd_1_222 VSS VDD sky130_fd_sc_hd__tapvpwrvgnd_1
* cell instance sky130_fd_sc_hd__tapvpwrvgnd_1_223 r0 *1 0,0
Xsky130_fd_sc_hd__tapvpwrvgnd_1_223 VSS VDD sky130_fd_sc_hd__tapvpwrvgnd_1
* cell instance sky130_fd_sc_hd__tapvpwrvgnd_1_224 r0 *1 0,0
Xsky130_fd_sc_hd__tapvpwrvgnd_1_224 VSS VDD sky130_fd_sc_hd__tapvpwrvgnd_1
* cell instance sky130_fd_sc_hd__tapvpwrvgnd_1_225 r0 *1 0,0
Xsky130_fd_sc_hd__tapvpwrvgnd_1_225 VSS VDD sky130_fd_sc_hd__tapvpwrvgnd_1
* cell instance sky130_fd_sc_hd__tapvpwrvgnd_1_226 r0 *1 0,0
Xsky130_fd_sc_hd__tapvpwrvgnd_1_226 VSS VDD sky130_fd_sc_hd__tapvpwrvgnd_1
* cell instance sky130_fd_sc_hd__tapvpwrvgnd_1_227 r0 *1 0,0
Xsky130_fd_sc_hd__tapvpwrvgnd_1_227 VSS VDD sky130_fd_sc_hd__tapvpwrvgnd_1
* cell instance sky130_fd_sc_hd__tapvpwrvgnd_1_228 r0 *1 0,0
Xsky130_fd_sc_hd__tapvpwrvgnd_1_228 VSS VDD sky130_fd_sc_hd__tapvpwrvgnd_1
* cell instance sky130_fd_sc_hd__tapvpwrvgnd_1_229 r0 *1 0,0
Xsky130_fd_sc_hd__tapvpwrvgnd_1_229 VSS VDD sky130_fd_sc_hd__tapvpwrvgnd_1
* cell instance sky130_fd_sc_hd__tapvpwrvgnd_1_230 r0 *1 0,0
Xsky130_fd_sc_hd__tapvpwrvgnd_1_230 VSS VDD sky130_fd_sc_hd__tapvpwrvgnd_1
* cell instance sky130_fd_sc_hd__tapvpwrvgnd_1_231 r0 *1 0,0
Xsky130_fd_sc_hd__tapvpwrvgnd_1_231 VSS VDD sky130_fd_sc_hd__tapvpwrvgnd_1
* cell instance sky130_fd_sc_hd__tapvpwrvgnd_1_232 r0 *1 0,0
Xsky130_fd_sc_hd__tapvpwrvgnd_1_232 VSS VDD sky130_fd_sc_hd__tapvpwrvgnd_1
* cell instance sky130_fd_sc_hd__tapvpwrvgnd_1_233 r0 *1 0,0
Xsky130_fd_sc_hd__tapvpwrvgnd_1_233 VSS VDD sky130_fd_sc_hd__tapvpwrvgnd_1
* cell instance sky130_fd_sc_hd__tapvpwrvgnd_1_234 r0 *1 0,0
Xsky130_fd_sc_hd__tapvpwrvgnd_1_234 VSS VDD sky130_fd_sc_hd__tapvpwrvgnd_1
* cell instance sky130_fd_sc_hd__tapvpwrvgnd_1_235 r0 *1 0,0
Xsky130_fd_sc_hd__tapvpwrvgnd_1_235 VSS VDD sky130_fd_sc_hd__tapvpwrvgnd_1
* cell instance sky130_fd_sc_hd__tapvpwrvgnd_1_236 r0 *1 0,0
Xsky130_fd_sc_hd__tapvpwrvgnd_1_236 VSS VDD sky130_fd_sc_hd__tapvpwrvgnd_1
* cell instance sky130_fd_sc_hd__tapvpwrvgnd_1_237 r0 *1 0,0
Xsky130_fd_sc_hd__tapvpwrvgnd_1_237 VSS VDD sky130_fd_sc_hd__tapvpwrvgnd_1
* cell instance sky130_fd_sc_hd__tapvpwrvgnd_1_238 r0 *1 0,0
Xsky130_fd_sc_hd__tapvpwrvgnd_1_238 VSS VDD sky130_fd_sc_hd__tapvpwrvgnd_1
* cell instance sky130_fd_sc_hd__tapvpwrvgnd_1_239 r0 *1 0,0
Xsky130_fd_sc_hd__tapvpwrvgnd_1_239 VSS VDD sky130_fd_sc_hd__tapvpwrvgnd_1
* cell instance sky130_fd_sc_hd__tapvpwrvgnd_1_240 r0 *1 0,0
Xsky130_fd_sc_hd__tapvpwrvgnd_1_240 VSS VDD sky130_fd_sc_hd__tapvpwrvgnd_1
* cell instance sky130_fd_sc_hd__tapvpwrvgnd_1_241 r0 *1 0,0
Xsky130_fd_sc_hd__tapvpwrvgnd_1_241 VSS VDD sky130_fd_sc_hd__tapvpwrvgnd_1
* cell instance sky130_fd_sc_hd__tapvpwrvgnd_1_242 r0 *1 0,0
Xsky130_fd_sc_hd__tapvpwrvgnd_1_242 VSS VDD sky130_fd_sc_hd__tapvpwrvgnd_1
* cell instance sky130_fd_sc_hd__tapvpwrvgnd_1_243 r0 *1 0,0
Xsky130_fd_sc_hd__tapvpwrvgnd_1_243 VSS VDD sky130_fd_sc_hd__tapvpwrvgnd_1
* cell instance sky130_fd_sc_hd__tapvpwrvgnd_1_244 r0 *1 0,0
Xsky130_fd_sc_hd__tapvpwrvgnd_1_244 VSS VDD sky130_fd_sc_hd__tapvpwrvgnd_1
* cell instance sky130_fd_sc_hd__tapvpwrvgnd_1_245 r0 *1 0,0
Xsky130_fd_sc_hd__tapvpwrvgnd_1_245 VSS VDD sky130_fd_sc_hd__tapvpwrvgnd_1
* cell instance sky130_fd_sc_hd__tapvpwrvgnd_1_246 r0 *1 0,0
Xsky130_fd_sc_hd__tapvpwrvgnd_1_246 VSS VDD sky130_fd_sc_hd__tapvpwrvgnd_1
* cell instance sky130_fd_sc_hd__tapvpwrvgnd_1_247 r0 *1 0,0
Xsky130_fd_sc_hd__tapvpwrvgnd_1_247 VSS VDD sky130_fd_sc_hd__tapvpwrvgnd_1
* cell instance sky130_fd_sc_hd__tapvpwrvgnd_1_248 r0 *1 0,0
Xsky130_fd_sc_hd__tapvpwrvgnd_1_248 VSS VDD sky130_fd_sc_hd__tapvpwrvgnd_1
* cell instance sky130_fd_sc_hd__tapvpwrvgnd_1_249 r0 *1 0,0
Xsky130_fd_sc_hd__tapvpwrvgnd_1_249 VSS VDD sky130_fd_sc_hd__tapvpwrvgnd_1
* cell instance sky130_fd_sc_hd__tapvpwrvgnd_1_250 r0 *1 0,0
Xsky130_fd_sc_hd__tapvpwrvgnd_1_250 VSS VDD sky130_fd_sc_hd__tapvpwrvgnd_1
* cell instance sky130_fd_sc_hd__tapvpwrvgnd_1_251 r0 *1 0,0
Xsky130_fd_sc_hd__tapvpwrvgnd_1_251 VSS VDD sky130_fd_sc_hd__tapvpwrvgnd_1
* cell instance sky130_fd_sc_hd__tapvpwrvgnd_1_252 r0 *1 0,0
Xsky130_fd_sc_hd__tapvpwrvgnd_1_252 VSS VDD sky130_fd_sc_hd__tapvpwrvgnd_1
* cell instance sky130_fd_sc_hd__tapvpwrvgnd_1_253 r0 *1 0,0
Xsky130_fd_sc_hd__tapvpwrvgnd_1_253 VSS VDD sky130_fd_sc_hd__tapvpwrvgnd_1
* cell instance sky130_fd_sc_hd__tapvpwrvgnd_1_254 r0 *1 0,0
Xsky130_fd_sc_hd__tapvpwrvgnd_1_254 VSS VDD sky130_fd_sc_hd__tapvpwrvgnd_1
* cell instance sky130_fd_sc_hd__tapvpwrvgnd_1_255 r0 *1 0,0
Xsky130_fd_sc_hd__tapvpwrvgnd_1_255 VSS VDD sky130_fd_sc_hd__tapvpwrvgnd_1
* cell instance sky130_fd_sc_hd__tapvpwrvgnd_1_256 r0 *1 0,0
Xsky130_fd_sc_hd__tapvpwrvgnd_1_256 VSS VDD sky130_fd_sc_hd__tapvpwrvgnd_1
* cell instance sky130_fd_sc_hd__tapvpwrvgnd_1_257 r0 *1 0,0
Xsky130_fd_sc_hd__tapvpwrvgnd_1_257 VSS VDD sky130_fd_sc_hd__tapvpwrvgnd_1
* cell instance sky130_fd_sc_hd__tapvpwrvgnd_1_258 r0 *1 0,0
Xsky130_fd_sc_hd__tapvpwrvgnd_1_258 VSS VDD sky130_fd_sc_hd__tapvpwrvgnd_1
* cell instance sky130_fd_sc_hd__tapvpwrvgnd_1_259 r0 *1 0,0
Xsky130_fd_sc_hd__tapvpwrvgnd_1_259 VSS VDD sky130_fd_sc_hd__tapvpwrvgnd_1
* cell instance sky130_fd_sc_hd__tapvpwrvgnd_1_260 r0 *1 0,0
Xsky130_fd_sc_hd__tapvpwrvgnd_1_260 VSS VDD sky130_fd_sc_hd__tapvpwrvgnd_1
* cell instance sky130_fd_sc_hd__tapvpwrvgnd_1_261 r0 *1 0,0
Xsky130_fd_sc_hd__tapvpwrvgnd_1_261 VSS VDD sky130_fd_sc_hd__tapvpwrvgnd_1
* cell instance sky130_fd_sc_hd__tapvpwrvgnd_1_262 r0 *1 0,0
Xsky130_fd_sc_hd__tapvpwrvgnd_1_262 VSS VDD sky130_fd_sc_hd__tapvpwrvgnd_1
* cell instance sky130_fd_sc_hd__tapvpwrvgnd_1_263 r0 *1 0,0
Xsky130_fd_sc_hd__tapvpwrvgnd_1_263 VSS VDD sky130_fd_sc_hd__tapvpwrvgnd_1
* cell instance sky130_fd_sc_hd__tapvpwrvgnd_1_264 r0 *1 0,0
Xsky130_fd_sc_hd__tapvpwrvgnd_1_264 VSS VDD sky130_fd_sc_hd__tapvpwrvgnd_1
* cell instance sky130_fd_sc_hd__xnor2_1_0 r0 *1 0,0
Xsky130_fd_sc_hd__xnor2_1_0 outer[3] \_0531_ VSS VDD VDD \_0532_
+ sky130_fd_sc_hd__xnor2_1
* cell instance sky130_fd_sc_hd__xnor2_1_1 r0 *1 0,0
Xsky130_fd_sc_hd__xnor2_1_1 outer[1] \_0530_ VSS VDD VDD \_0537_
+ sky130_fd_sc_hd__xnor2_1
* cell instance sky130_fd_sc_hd__xnor2_1_2 r0 *1 0,0
Xsky130_fd_sc_hd__xnor2_1_2 \_0258_ \_0259_ VSS VDD VDD \_0426_
+ sky130_fd_sc_hd__xnor2_1
* cell instance sky130_fd_sc_hd__xnor2_1_3 r0 *1 0,0
Xsky130_fd_sc_hd__xnor2_1_3 mod_r[1] \_0257_ VSS VDD VDD \_0314_
+ sky130_fd_sc_hd__xnor2_1
* cell instance sky130_fd_sc_hd__xnor2_1_4 r0 *1 0,0
Xsky130_fd_sc_hd__xnor2_1_4 \_0313_ \_0314_ VSS VDD VDD \_0429_
+ sky130_fd_sc_hd__xnor2_1
* cell instance sky130_fd_sc_hd__xnor2_1_5 r0 *1 0,0
Xsky130_fd_sc_hd__xnor2_1_5 \_0315_ \_0316_ VSS VDD VDD \_0423_
+ sky130_fd_sc_hd__xnor2_1
* cell instance sky130_fd_sc_hd__xnor2_1_6 r0 *1 0,0
Xsky130_fd_sc_hd__xnor2_1_6 mod_r[2] \_0254_ VSS VDD VDD \_0261_
+ sky130_fd_sc_hd__xnor2_1
* cell instance sky130_fd_sc_hd__xnor2_1_7 r0 *1 0,0
Xsky130_fd_sc_hd__xnor2_1_7 \_0260_ \_0261_ VSS VDD VDD \_0419_
+ sky130_fd_sc_hd__xnor2_1
* cell instance sky130_fd_sc_hd__xnor2_1_8 r0 *1 0,0
Xsky130_fd_sc_hd__xnor2_1_8 \_0308_ \_0319_ VSS VDD VDD \_0410_
+ sky130_fd_sc_hd__xnor2_1
* cell instance sky130_fd_sc_hd__xnor2_1_9 r0 *1 0,0
Xsky130_fd_sc_hd__xnor2_1_9 \_0205_ \_0252_ VSS VDD VDD \_0253_
+ sky130_fd_sc_hd__xnor2_1
* cell instance sky130_fd_sc_hd__xnor2_1_10 r0 *1 0,0
Xsky130_fd_sc_hd__xnor2_1_10 mod_r[3] \_0253_ VSS VDD VDD \_0413_
+ sky130_fd_sc_hd__xnor2_1
* cell instance sky130_fd_sc_hd__xnor2_1_11 r0 *1 0,0
Xsky130_fd_sc_hd__xnor2_1_11 \_0202_ \_0204_ VSS VDD VDD \_0254_
+ sky130_fd_sc_hd__xnor2_1
* cell instance sky130_fd_sc_hd__xnor2_1_12 r0 *1 0,0
Xsky130_fd_sc_hd__xnor2_1_12 \_0304_ \_0322_ VSS VDD VDD \_0397_
+ sky130_fd_sc_hd__xnor2_1
* cell instance sky130_fd_sc_hd__xnor2_1_13 r0 *1 0,0
Xsky130_fd_sc_hd__xnor2_1_13 \_0208_ \_0245_ VSS VDD VDD \_0246_
+ sky130_fd_sc_hd__xnor2_1
* cell instance sky130_fd_sc_hd__xnor2_1_14 r0 *1 0,0
Xsky130_fd_sc_hd__xnor2_1_14 mod_r[7] \_0239_ VSS VDD VDD \_0268_
+ sky130_fd_sc_hd__xnor2_1
* cell instance sky130_fd_sc_hd__xnor2_1_15 r0 *1 0,0
Xsky130_fd_sc_hd__xnor2_1_15 \_0185_ \_0211_ VSS VDD VDD \_0239_
+ sky130_fd_sc_hd__xnor2_1
* cell instance sky130_fd_sc_hd__xnor2_1_16 r0 *1 0,0
Xsky130_fd_sc_hd__xnor2_1_16 mod_r[8] \_0239_ VSS VDD VDD \_0327_
+ sky130_fd_sc_hd__xnor2_1
* cell instance sky130_fd_sc_hd__xnor2_1_17 r0 *1 0,0
Xsky130_fd_sc_hd__xnor2_1_17 mm_p[7] \_0183_ VSS VDD VDD \_0185_
+ sky130_fd_sc_hd__xnor2_1
* cell instance sky130_fd_sc_hd__xnor2_1_18 r0 *1 0,0
Xsky130_fd_sc_hd__xnor2_1_18 mod_r[8] \_0237_ VSS VDD VDD \_0270_
+ sky130_fd_sc_hd__xnor2_1
* cell instance sky130_fd_sc_hd__xnor2_1_19 r0 *1 0,0
Xsky130_fd_sc_hd__xnor2_1_19 mm_p[8] \_0180_ VSS VDD VDD \_0182_
+ sky130_fd_sc_hd__xnor2_1
* cell instance sky130_fd_sc_hd__xnor2_1_20 r0 *1 0,0
Xsky130_fd_sc_hd__xnor2_1_20 \_0182_ \_0212_ VSS VDD VDD \_0237_
+ sky130_fd_sc_hd__xnor2_1
* cell instance sky130_fd_sc_hd__xnor2_1_21 r0 *1 0,0
Xsky130_fd_sc_hd__xnor2_1_21 \_0296_ \_0330_ VSS VDD VDD \_0373_
+ sky130_fd_sc_hd__xnor2_1
* cell instance sky130_fd_sc_hd__xnor2_1_22 r0 *1 0,0
Xsky130_fd_sc_hd__xnor2_1_22 \_0176_ \_0214_ VSS VDD VDD \_0232_
+ sky130_fd_sc_hd__xnor2_1
* cell instance sky130_fd_sc_hd__xnor2_1_23 r0 *1 0,0
Xsky130_fd_sc_hd__xnor2_1_23 mod_r[11] \_0230_ VSS VDD VDD \_0277_
+ sky130_fd_sc_hd__xnor2_1
* cell instance sky130_fd_sc_hd__xnor2_1_24 r0 *1 0,0
Xsky130_fd_sc_hd__xnor2_1_24 \_0218_ \_0224_ VSS VDD VDD \_0225_
+ sky130_fd_sc_hd__xnor2_1
* cell instance sky130_fd_sc_hd__xnor2_1_25 r0 *1 0,0
Xsky130_fd_sc_hd__xnor2_1_25 \_0166_ \_0219_ VSS VDD VDD \_0283_
+ sky130_fd_sc_hd__xnor2_1
* cell instance sky130_fd_sc_hd__xnor2_1_26 r0 *1 0,0
Xsky130_fd_sc_hd__xnor2_1_26 mod_r[14] \_0225_ VSS VDD VDD \_0339_
+ sky130_fd_sc_hd__xnor2_1
* cell instance sky130_fd_sc_hd__xnor2_1_27 r0 *1 0,0
Xsky130_fd_sc_hd__xnor2_1_27 mod_r[15] \_0283_ VSS VDD VDD \_0342_
+ sky130_fd_sc_hd__xnor2_1
* cell instance sky130_fd_sc_hd__xnor2_1_28 r0 *1 0,0
Xsky130_fd_sc_hd__xnor2_1_28 mod_r[14] \_0283_ VSS VDD VDD \_0284_
+ sky130_fd_sc_hd__xnor2_1
* cell instance sky130_fd_sc_hd__xnor3_1_0 r0 *1 0,0
Xsky130_fd_sc_hd__xnor3_1_0 mm_p[1] \_0198_ \_0200_ VSS VDD VDD \_0255_
+ sky130_fd_sc_hd__xnor3_1
* cell instance sky130_fd_sc_hd__xnor3_1_1 r0 *1 0,0
Xsky130_fd_sc_hd__xnor3_1_1 mod_r[4] \_0205_ \_0252_ VSS VDD VDD \_0308_
+ sky130_fd_sc_hd__xnor3_1
* cell instance sky130_fd_sc_hd__xnor3_1_2 r0 *1 0,0
Xsky130_fd_sc_hd__xnor3_1_2 mod_r[6] \_0188_ \_0210_ VSS VDD VDD \_0244_
+ sky130_fd_sc_hd__xnor3_1
* cell instance sky130_fd_sc_hd__xnor3_1_3 r0 *1 0,0
Xsky130_fd_sc_hd__xnor3_1_3 mod_r[7] \_0188_ \_0210_ VSS VDD VDD \_0324_
+ sky130_fd_sc_hd__xnor3_1
* cell instance sky130_fd_sc_hd__xnor3_1_4 r0 *1 0,0
Xsky130_fd_sc_hd__xnor3_1_4 mod_r[10] \_0179_ \_0213_ VSS VDD VDD \_0296_
+ sky130_fd_sc_hd__xnor3_1
* cell instance sky130_fd_sc_hd__xnor3_1_5 r0 *1 0,0
Xsky130_fd_sc_hd__xnor3_1_5 mod_r[11] \_0176_ \_0214_ VSS VDD VDD \_0332_
+ sky130_fd_sc_hd__xnor3_1
* cell instance sky130_fd_sc_hd__xnor3_1_6 r0 *1 0,0
Xsky130_fd_sc_hd__xnor3_1_6 mod_r[13] \_0171_ \_0217_ VSS VDD VDD \_0337_
+ sky130_fd_sc_hd__xnor3_1
* cell instance sky130_fd_sc_hd__xor2_1_0 r0 *1 0,0
Xsky130_fd_sc_hd__xor2_1_0 j[4] \_0156_ VSS VDD VDD \_0535_
+ sky130_fd_sc_hd__xor2_1
* cell instance sky130_fd_sc_hd__xor2_1_1 r0 *1 0,0
Xsky130_fd_sc_hd__xor2_1_1 mod_r[1] \_0255_ VSS VDD VDD \_0259_
+ sky130_fd_sc_hd__xor2_1
* cell instance sky130_fd_sc_hd__xor2_1_2 r0 *1 0,0
Xsky130_fd_sc_hd__xor2_1_2 mod_r[2] \_0255_ VSS VDD VDD \_0316_
+ sky130_fd_sc_hd__xor2_1
* cell instance sky130_fd_sc_hd__xor2_1_3 r0 *1 0,0
Xsky130_fd_sc_hd__xor2_1_3 \_0318_ \_0416_ VSS VDD VDD \_0417_
+ sky130_fd_sc_hd__xor2_1
* cell instance sky130_fd_sc_hd__xor2_1_4 r0 *1 0,0
Xsky130_fd_sc_hd__xor2_1_4 mod_r[4] \_0250_ VSS VDD VDD \_0251_
+ sky130_fd_sc_hd__xor2_1
* cell instance sky130_fd_sc_hd__xor2_1_5 r0 *1 0,0
Xsky130_fd_sc_hd__xor2_1_5 \_0251_ \_0263_ VSS VDD VDD \_0406_
+ sky130_fd_sc_hd__xor2_1
* cell instance sky130_fd_sc_hd__xor2_1_6 r0 *1 0,0
Xsky130_fd_sc_hd__xor2_1_6 \_0262_ \_0413_ VSS VDD VDD \_0414_
+ sky130_fd_sc_hd__xor2_1
* cell instance sky130_fd_sc_hd__xor2_1_7 r0 *1 0,0
Xsky130_fd_sc_hd__xor2_1_7 \_0321_ \_0403_ VSS VDD VDD \_0404_
+ sky130_fd_sc_hd__xor2_1
* cell instance sky130_fd_sc_hd__xor2_1_8 r0 *1 0,0
Xsky130_fd_sc_hd__xor2_1_8 \_0264_ \_0400_ VSS VDD VDD \_0401_
+ sky130_fd_sc_hd__xor2_1
* cell instance sky130_fd_sc_hd__xor2_1_9 r0 *1 0,0
Xsky130_fd_sc_hd__xor2_1_9 \_0244_ \_0265_ VSS VDD VDD \_0394_
+ sky130_fd_sc_hd__xor2_1
* cell instance sky130_fd_sc_hd__xor2_1_10 r0 *1 0,0
Xsky130_fd_sc_hd__xor2_1_10 \_0188_ \_0210_ VSS VDD VDD \_0242_
+ sky130_fd_sc_hd__xor2_1
* cell instance sky130_fd_sc_hd__xor2_1_11 r0 *1 0,0
Xsky130_fd_sc_hd__xor2_1_11 \_0267_ \_0268_ VSS VDD VDD \_0389_
+ sky130_fd_sc_hd__xor2_1
* cell instance sky130_fd_sc_hd__xor2_1_12 r0 *1 0,0
Xsky130_fd_sc_hd__xor2_1_12 \_0179_ \_0213_ VSS VDD VDD \_0234_
+ sky130_fd_sc_hd__xor2_1
* cell instance sky130_fd_sc_hd__xor2_1_13 r0 *1 0,0
Xsky130_fd_sc_hd__xor2_1_13 mm_p[9] \_0177_ VSS VDD VDD \_0179_
+ sky130_fd_sc_hd__xor2_1
* cell instance sky130_fd_sc_hd__xor2_1_14 r0 *1 0,0
Xsky130_fd_sc_hd__xor2_1_14 \_0215_ \_0229_ VSS VDD VDD \_0230_
+ sky130_fd_sc_hd__xor2_1
* cell instance sky130_fd_sc_hd__xor2_1_15 r0 *1 0,0
Xsky130_fd_sc_hd__xor2_1_15 \_0336_ \_0337_ VSS VDD VDD \_0353_
+ sky130_fd_sc_hd__xor2_1
* cell instance sky130_fd_sc_hd__xor2_1_16 r0 *1 0,0
Xsky130_fd_sc_hd__xor2_1_16 \_0171_ \_0217_ VSS VDD VDD \_0227_
+ sky130_fd_sc_hd__xor2_1
* cell instance sky130_fd_sc_hd__xor2_1_17 r0 *1 0,0
Xsky130_fd_sc_hd__xor2_1_17 mod_r[12] \_0227_ VSS VDD VDD \_0279_
+ sky130_fd_sc_hd__xor2_1
* cell instance sky130_fd_sc_hd__xor2_1_18 r0 *1 0,0
Xsky130_fd_sc_hd__xor2_1_18 mod_r[13] \_0225_ VSS VDD VDD \_0281_
+ sky130_fd_sc_hd__xor2_1
* cell instance sky130_fd_sc_hd__xor3_1_0 r0 *1 0,0
Xsky130_fd_sc_hd__xor3_1_0 mod_r[6] \_0208_ \_0245_ VSS VDD VDD \_0304_
+ sky130_fd_sc_hd__xor3_1
* cell instance sky130_fd_sc_hd__xor3_1_1 r0 *1 0,0
Xsky130_fd_sc_hd__xor3_1_1 mod_r[9] \_0234_ \_0272_ VSS VDD VDD \_0376_
+ sky130_fd_sc_hd__xor3_1
* cell instance sky130_fd_sc_hd__xor3_1_2 r0 *1 0,0
Xsky130_fd_sc_hd__xor3_1_2 mod_r[12] \_0215_ \_0229_ VSS VDD VDD \_0334_
+ sky130_fd_sc_hd__xor3_1
.ENDS modexp

* cell sky130_fd_sc_hd__xor3_1
* pin A
* pin B
* pin C
* pin VGND
* pin VPB
* pin VPWR
* pin X
.SUBCKT sky130_fd_sc_hd__xor3_1 A B C VGND VPB VPWR X
.ENDS sky130_fd_sc_hd__xor3_1

* cell sky130_fd_sc_hd__xor2_1
* pin A
* pin B
* pin VGND
* pin VPB
* pin VPWR
* pin X
.SUBCKT sky130_fd_sc_hd__xor2_1 A B VGND VPB VPWR X
.ENDS sky130_fd_sc_hd__xor2_1

* cell sky130_fd_sc_hd__xnor3_1
* pin A
* pin B
* pin C
* pin VGND
* pin VPB
* pin VPWR
* pin X
.SUBCKT sky130_fd_sc_hd__xnor3_1 A B C VGND VPB VPWR X
.ENDS sky130_fd_sc_hd__xnor3_1

* cell sky130_fd_sc_hd__xnor2_1
* pin A
* pin B
* pin VGND
* pin VPB
* pin VPWR
* pin Y
.SUBCKT sky130_fd_sc_hd__xnor2_1 A B VGND VPB VPWR Y
.ENDS sky130_fd_sc_hd__xnor2_1

* cell sky130_fd_sc_hd__tapvpwrvgnd_1
* pin VGND
* pin VPWR
.SUBCKT sky130_fd_sc_hd__tapvpwrvgnd_1 VGND VPWR
.ENDS sky130_fd_sc_hd__tapvpwrvgnd_1

* cell sky130_fd_sc_hd__or4_1
* pin A
* pin B
* pin C
* pin D
* pin VGND
* pin VPB
* pin VPWR
* pin X
.SUBCKT sky130_fd_sc_hd__or4_1 A B C D VGND VPB VPWR X
.ENDS sky130_fd_sc_hd__or4_1

* cell sky130_fd_sc_hd__or3_1
* pin A
* pin B
* pin C
* pin VGND
* pin VPB
* pin VPWR
* pin X
.SUBCKT sky130_fd_sc_hd__or3_1 A B C VGND VPB VPWR X
.ENDS sky130_fd_sc_hd__or3_1

* cell sky130_fd_sc_hd__o31ai_1
* pin A1
* pin A2
* pin A3
* pin B1
* pin VGND
* pin VPB
* pin VPWR
* pin Y
.SUBCKT sky130_fd_sc_hd__o31ai_1 A1 A2 A3 B1 VGND VPB VPWR Y
.ENDS sky130_fd_sc_hd__o31ai_1

* cell sky130_fd_sc_hd__o31a_1
* pin A1
* pin A2
* pin A3
* pin B1
* pin VGND
* pin VPB
* pin VPWR
* pin X
.SUBCKT sky130_fd_sc_hd__o31a_1 A1 A2 A3 B1 VGND VPB VPWR X
.ENDS sky130_fd_sc_hd__o31a_1

* cell sky130_fd_sc_hd__o311ai_0
* pin A1
* pin A2
* pin A3
* pin B1
* pin C1
* pin VGND
* pin VPB
* pin VPWR
* pin Y
.SUBCKT sky130_fd_sc_hd__o311ai_0 A1 A2 A3 B1 C1 VGND VPB VPWR Y
.ENDS sky130_fd_sc_hd__o311ai_0

* cell sky130_fd_sc_hd__o311a_1
* pin A1
* pin A2
* pin A3
* pin B1
* pin C1
* pin VGND
* pin VPB
* pin VPWR
* pin X
.SUBCKT sky130_fd_sc_hd__o311a_1 A1 A2 A3 B1 C1 VGND VPB VPWR X
.ENDS sky130_fd_sc_hd__o311a_1

* cell sky130_fd_sc_hd__o22ai_2
* pin A1
* pin A2
* pin B1
* pin B2
* pin VGND
* pin VPB
* pin VPWR
* pin Y
.SUBCKT sky130_fd_sc_hd__o22ai_2 A1 A2 B1 B2 VGND VPB VPWR Y
.ENDS sky130_fd_sc_hd__o22ai_2

* cell sky130_fd_sc_hd__o21bai_1
* pin A1
* pin A2
* pin B1_N
* pin VGND
* pin VPB
* pin VPWR
* pin Y
.SUBCKT sky130_fd_sc_hd__o21bai_1 A1 A2 B1_N VGND VPB VPWR Y
.ENDS sky130_fd_sc_hd__o21bai_1

* cell sky130_fd_sc_hd__o21ai_2
* pin A1
* pin A2
* pin B1
* pin VGND
* pin VPB
* pin VPWR
* pin Y
.SUBCKT sky130_fd_sc_hd__o21ai_2 A1 A2 B1 VGND VPB VPWR Y
.ENDS sky130_fd_sc_hd__o21ai_2

* cell sky130_fd_sc_hd__o21ai_0
* pin A1
* pin A2
* pin B1
* pin VGND
* pin VPB
* pin VPWR
* pin Y
.SUBCKT sky130_fd_sc_hd__o21ai_0 A1 A2 B1 VGND VPB VPWR Y
.ENDS sky130_fd_sc_hd__o21ai_0

* cell sky130_fd_sc_hd__o21a_1
* pin A1
* pin A2
* pin B1
* pin VGND
* pin VPB
* pin VPWR
* pin X
.SUBCKT sky130_fd_sc_hd__o21a_1 A1 A2 B1 VGND VPB VPWR X
.ENDS sky130_fd_sc_hd__o21a_1

* cell sky130_fd_sc_hd__o211ai_1
* pin A1
* pin A2
* pin B1
* pin C1
* pin VGND
* pin VPB
* pin VPWR
* pin Y
.SUBCKT sky130_fd_sc_hd__o211ai_1 A1 A2 B1 C1 VGND VPB VPWR Y
.ENDS sky130_fd_sc_hd__o211ai_1

* cell sky130_fd_sc_hd__o211a_1
* pin A1
* pin A2
* pin B1
* pin C1
* pin VGND
* pin VPB
* pin VPWR
* pin X
.SUBCKT sky130_fd_sc_hd__o211a_1 A1 A2 B1 C1 VGND VPB VPWR X
.ENDS sky130_fd_sc_hd__o211a_1

* cell sky130_fd_sc_hd__nor4_1
* pin A
* pin B
* pin C
* pin D
* pin VGND
* pin VPB
* pin VPWR
* pin Y
.SUBCKT sky130_fd_sc_hd__nor4_1 A B C D VGND VPB VPWR Y
.ENDS sky130_fd_sc_hd__nor4_1

* cell sky130_fd_sc_hd__nor3_1
* pin A
* pin B
* pin C
* pin VGND
* pin VPB
* pin VPWR
* pin Y
.SUBCKT sky130_fd_sc_hd__nor3_1 A B C VGND VPB VPWR Y
.ENDS sky130_fd_sc_hd__nor3_1

* cell sky130_fd_sc_hd__nor2b_1
* pin A
* pin B_N
* pin VGND
* pin VPB
* pin VPWR
* pin Y
.SUBCKT sky130_fd_sc_hd__nor2b_1 A B_N VGND VPB VPWR Y
.ENDS sky130_fd_sc_hd__nor2b_1

* cell sky130_fd_sc_hd__nor2_2
* pin A
* pin B
* pin VGND
* pin VPB
* pin VPWR
* pin Y
.SUBCKT sky130_fd_sc_hd__nor2_2 A B VGND VPB VPWR Y
.ENDS sky130_fd_sc_hd__nor2_2

* cell sky130_fd_sc_hd__nor2_1
* pin A
* pin B
* pin VGND
* pin VPB
* pin VPWR
* pin Y
.SUBCKT sky130_fd_sc_hd__nor2_1 A B VGND VPB VPWR Y
.ENDS sky130_fd_sc_hd__nor2_1

* cell sky130_fd_sc_hd__nand3b_1
* pin A_N
* pin B
* pin C
* pin VGND
* pin VPB
* pin VPWR
* pin Y
.SUBCKT sky130_fd_sc_hd__nand3b_1 A_N B C VGND VPB VPWR Y
.ENDS sky130_fd_sc_hd__nand3b_1

* cell sky130_fd_sc_hd__nand3_1
* pin A
* pin B
* pin C
* pin VGND
* pin VPB
* pin VPWR
* pin Y
.SUBCKT sky130_fd_sc_hd__nand3_1 A B C VGND VPB VPWR Y
.ENDS sky130_fd_sc_hd__nand3_1

* cell sky130_fd_sc_hd__nand2b_1
* pin A_N
* pin B
* pin VGND
* pin VPB
* pin VPWR
* pin Y
.SUBCKT sky130_fd_sc_hd__nand2b_1 A_N B VGND VPB VPWR Y
.ENDS sky130_fd_sc_hd__nand2b_1

* cell sky130_fd_sc_hd__nand2_1
* pin A
* pin B
* pin VGND
* pin VPB
* pin VPWR
* pin Y
.SUBCKT sky130_fd_sc_hd__nand2_1 A B VGND VPB VPWR Y
.ENDS sky130_fd_sc_hd__nand2_1

* cell sky130_fd_sc_hd__mux2i_1
* pin A0
* pin A1
* pin S
* pin VGND
* pin VPB
* pin VPWR
* pin Y
.SUBCKT sky130_fd_sc_hd__mux2i_1 A0 A1 S VGND VPB VPWR Y
.ENDS sky130_fd_sc_hd__mux2i_1

* cell sky130_fd_sc_hd__mux2_1
* pin A0
* pin A1
* pin S
* pin VGND
* pin VPB
* pin VPWR
* pin X
.SUBCKT sky130_fd_sc_hd__mux2_1 A0 A1 S VGND VPB VPWR X
.ENDS sky130_fd_sc_hd__mux2_1

* cell sky130_fd_sc_hd__maj3_1
* pin A
* pin B
* pin C
* pin VGND
* pin VPB
* pin VPWR
* pin X
.SUBCKT sky130_fd_sc_hd__maj3_1 A B C VGND VPB VPWR X
.ENDS sky130_fd_sc_hd__maj3_1

* cell sky130_fd_sc_hd__lpflow_isobufsrc_1
* pin A
* pin SLEEP
* pin VGND
* pin VPB
* pin VPWR
* pin X
.SUBCKT sky130_fd_sc_hd__lpflow_isobufsrc_1 A SLEEP VGND VPB VPWR X
.ENDS sky130_fd_sc_hd__lpflow_isobufsrc_1

* cell sky130_fd_sc_hd__lpflow_inputiso1p_1
* pin A
* pin SLEEP
* pin VGND
* pin VPB
* pin VPWR
* pin X
.SUBCKT sky130_fd_sc_hd__lpflow_inputiso1p_1 A SLEEP VGND VPB VPWR X
.ENDS sky130_fd_sc_hd__lpflow_inputiso1p_1

* cell sky130_fd_sc_hd__inv_6
* pin A
* pin VGND
* pin VPB
* pin VPWR
* pin Y
.SUBCKT sky130_fd_sc_hd__inv_6 A VGND VPB VPWR Y
.ENDS sky130_fd_sc_hd__inv_6

* cell sky130_fd_sc_hd__inv_1
* pin A
* pin VGND
* pin VPB
* pin VPWR
* pin Y
.SUBCKT sky130_fd_sc_hd__inv_1 A VGND VPB VPWR Y
.ENDS sky130_fd_sc_hd__inv_1

* cell sky130_fd_sc_hd__fill_8
* pin VGND
* pin VPB
* pin VPWR
.SUBCKT sky130_fd_sc_hd__fill_8 VGND VPB VPWR
.ENDS sky130_fd_sc_hd__fill_8

* cell sky130_fd_sc_hd__fill_4
* pin VGND
* pin VPB
* pin VPWR
.SUBCKT sky130_fd_sc_hd__fill_4 VGND VPB VPWR
.ENDS sky130_fd_sc_hd__fill_4

* cell sky130_fd_sc_hd__fill_2
* pin VGND
* pin VPB
* pin VPWR
.SUBCKT sky130_fd_sc_hd__fill_2 VGND VPB VPWR
.ENDS sky130_fd_sc_hd__fill_2

* cell sky130_fd_sc_hd__fill_1
* pin VGND
* pin VPB
* pin VPWR
.SUBCKT sky130_fd_sc_hd__fill_1 VGND VPB VPWR
.ENDS sky130_fd_sc_hd__fill_1

* cell sky130_fd_sc_hd__diode_2
* pin DIODE
* pin VGND
* pin VPB
* pin VPWR
.SUBCKT sky130_fd_sc_hd__diode_2 DIODE VGND VPB VPWR
.ENDS sky130_fd_sc_hd__diode_2

* cell sky130_fd_sc_hd__dfstp_2
* pin CLK
* pin D
* pin Q
* pin SET_B
* pin VGND
* pin VPB
* pin VPWR
.SUBCKT sky130_fd_sc_hd__dfstp_2 CLK D Q SET_B VGND VPB VPWR
.ENDS sky130_fd_sc_hd__dfstp_2

* cell sky130_fd_sc_hd__dfrtp_1
* pin CLK
* pin D
* pin Q
* pin RESET_B
* pin VGND
* pin VPB
* pin VPWR
.SUBCKT sky130_fd_sc_hd__dfrtp_1 CLK D Q RESET_B VGND VPB VPWR
.ENDS sky130_fd_sc_hd__dfrtp_1

* cell sky130_fd_sc_hd__conb_1
* pin HI
* pin LO
* pin VGND
* pin VPB
* pin VPWR
.SUBCKT sky130_fd_sc_hd__conb_1 HI LO VGND VPB VPWR
.ENDS sky130_fd_sc_hd__conb_1

* cell sky130_fd_sc_hd__clkinv_4
* pin A
* pin VGND
* pin VPB
* pin VPWR
* pin Y
.SUBCKT sky130_fd_sc_hd__clkinv_4 A VGND VPB VPWR Y
.ENDS sky130_fd_sc_hd__clkinv_4

* cell sky130_fd_sc_hd__clkinv_2
* pin A
* pin VGND
* pin VPB
* pin VPWR
* pin Y
.SUBCKT sky130_fd_sc_hd__clkinv_2 A VGND VPB VPWR Y
.ENDS sky130_fd_sc_hd__clkinv_2

* cell sky130_fd_sc_hd__clkinv_1
* pin A
* pin VGND
* pin VPB
* pin VPWR
* pin Y
.SUBCKT sky130_fd_sc_hd__clkinv_1 A VGND VPB VPWR Y
.ENDS sky130_fd_sc_hd__clkinv_1

* cell sky130_fd_sc_hd__bufinv_16
* pin A
* pin VGND
* pin VPB
* pin VPWR
* pin Y
.SUBCKT sky130_fd_sc_hd__bufinv_16 A VGND VPB VPWR Y
.ENDS sky130_fd_sc_hd__bufinv_16

* cell sky130_fd_sc_hd__buf_4
* pin A
* pin VGND
* pin VPB
* pin VPWR
* pin X
.SUBCKT sky130_fd_sc_hd__buf_4 A VGND VPB VPWR X
.ENDS sky130_fd_sc_hd__buf_4

* cell sky130_fd_sc_hd__and3_1
* pin A
* pin B
* pin C
* pin VGND
* pin VPB
* pin VPWR
* pin X
.SUBCKT sky130_fd_sc_hd__and3_1 A B C VGND VPB VPWR X
.ENDS sky130_fd_sc_hd__and3_1

* cell sky130_fd_sc_hd__and2_0
* pin A
* pin B
* pin VGND
* pin VPB
* pin VPWR
* pin X
.SUBCKT sky130_fd_sc_hd__and2_0 A B VGND VPB VPWR X
.ENDS sky130_fd_sc_hd__and2_0

* cell sky130_fd_sc_hd__a32o_1
* pin A1
* pin A2
* pin A3
* pin B1
* pin B2
* pin VGND
* pin VPB
* pin VPWR
* pin X
.SUBCKT sky130_fd_sc_hd__a32o_1 A1 A2 A3 B1 B2 VGND VPB VPWR X
.ENDS sky130_fd_sc_hd__a32o_1

* cell sky130_fd_sc_hd__a31oi_1
* pin A1
* pin A2
* pin A3
* pin B1
* pin VGND
* pin VPB
* pin VPWR
* pin Y
.SUBCKT sky130_fd_sc_hd__a31oi_1 A1 A2 A3 B1 VGND VPB VPWR Y
.ENDS sky130_fd_sc_hd__a31oi_1

* cell sky130_fd_sc_hd__a31o_1
* pin A1
* pin A2
* pin A3
* pin B1
* pin VGND
* pin VPB
* pin VPWR
* pin X
.SUBCKT sky130_fd_sc_hd__a31o_1 A1 A2 A3 B1 VGND VPB VPWR X
.ENDS sky130_fd_sc_hd__a31o_1

* cell sky130_fd_sc_hd__a311oi_1
* pin A1
* pin A2
* pin A3
* pin B1
* pin C1
* pin VGND
* pin VPB
* pin VPWR
* pin Y
.SUBCKT sky130_fd_sc_hd__a311oi_1 A1 A2 A3 B1 C1 VGND VPB VPWR Y
.ENDS sky130_fd_sc_hd__a311oi_1

* cell sky130_fd_sc_hd__a311o_1
* pin A1
* pin A2
* pin A3
* pin B1
* pin C1
* pin VGND
* pin VPB
* pin VPWR
* pin X
.SUBCKT sky130_fd_sc_hd__a311o_1 A1 A2 A3 B1 C1 VGND VPB VPWR X
.ENDS sky130_fd_sc_hd__a311o_1

* cell sky130_fd_sc_hd__a22o_1
* pin A1
* pin A2
* pin B1
* pin B2
* pin VGND
* pin VPB
* pin VPWR
* pin X
.SUBCKT sky130_fd_sc_hd__a22o_1 A1 A2 B1 B2 VGND VPB VPWR X
.ENDS sky130_fd_sc_hd__a22o_1

* cell sky130_fd_sc_hd__a222oi_1
* pin A1
* pin A2
* pin B1
* pin B2
* pin C1
* pin C2
* pin VGND
* pin VPB
* pin VPWR
* pin Y
.SUBCKT sky130_fd_sc_hd__a222oi_1 A1 A2 B1 B2 C1 C2 VGND VPB VPWR Y
.ENDS sky130_fd_sc_hd__a222oi_1

* cell sky130_fd_sc_hd__a21oi_1
* pin A1
* pin A2
* pin B1
* pin VGND
* pin VPB
* pin VPWR
* pin Y
.SUBCKT sky130_fd_sc_hd__a21oi_1 A1 A2 B1 VGND VPB VPWR Y
.ENDS sky130_fd_sc_hd__a21oi_1

* cell sky130_fd_sc_hd__a21o_1
* pin A1
* pin A2
* pin B1
* pin VGND
* pin VPB
* pin VPWR
* pin X
.SUBCKT sky130_fd_sc_hd__a21o_1 A1 A2 B1 VGND VPB VPWR X
.ENDS sky130_fd_sc_hd__a21o_1

* cell sky130_fd_sc_hd__a21boi_0
* pin A1
* pin A2
* pin B1_N
* pin VGND
* pin VPB
* pin VPWR
* pin Y
.SUBCKT sky130_fd_sc_hd__a21boi_0 A1 A2 B1_N VGND VPB VPWR Y
.ENDS sky130_fd_sc_hd__a21boi_0

* cell sky130_fd_sc_hd__a211oi_1
* pin A1
* pin A2
* pin B1
* pin C1
* pin VGND
* pin VPB
* pin VPWR
* pin Y
.SUBCKT sky130_fd_sc_hd__a211oi_1 A1 A2 B1 C1 VGND VPB VPWR Y
.ENDS sky130_fd_sc_hd__a211oi_1

* cell sky130_fd_sc_hd__a211o_1
* pin A1
* pin A2
* pin B1
* pin C1
* pin VGND
* pin VPB
* pin VPWR
* pin X
.SUBCKT sky130_fd_sc_hd__a211o_1 A1 A2 B1 C1 VGND VPB VPWR X
.ENDS sky130_fd_sc_hd__a211o_1
