* golden reference netlist, built from klt synthesize's gate-level
* Verilog netlist (verification/records/place-and-route/artifacts/
* 20260814-203901-c741877/modexp_synth_tied.v) --
* see layout/lvs/README.md for how this file is produced and its
* documented scope (pre-CTS logical netlist; VPWR/VGND/VPB/VNB tied
* to one ideal global net per name, since the gate netlist carries no
* power connectivity at all).

.SUBCKT modexp VDD VSS base_in[0] base_in[10] base_in[11] base_in[12] base_in[13] base_in[14] base_in[15] base_in[1] base_in[2] base_in[3] base_in[4] base_in[5] base_in[6] base_in[7] base_in[8] base_in[9] clk done exp_in[0] exp_in[10] exp_in[11] exp_in[12] exp_in[13] exp_in[14] exp_in[15] exp_in[1] exp_in[2] exp_in[3] exp_in[4] exp_in[5] exp_in[6] exp_in[7] exp_in[8] exp_in[9] mod_in[0] mod_in[10] mod_in[11] mod_in[12] mod_in[13] mod_in[14] mod_in[15] mod_in[1] mod_in[2] mod_in[3] mod_in[4] mod_in[5] mod_in[6] mod_in[7] mod_in[8] mod_in[9] result[0] result[10] result[11] result[12] result[13] result[14] result[15] result[1] result[2] result[3] result[4] result[5] result[6] result[7] result[8] result[9] rst_n start
XANTENNA_1 mod_in[8] VSS VDD VDD sky130_fd_sc_hd__diode_2
X_0588_ outer[1] outer[0] VSS VDD VDD _0130_ sky130_fd_sc_hd__nand2b_1
X_0589_ outer[2] outer[3] outer[4] _0130_ VSS VDD VDD _0131_ sky130_fd_sc_hd__nor4_1
X_0590_ state[1] _0131_ VSS VDD VDD _0132_ sky130_fd_sc_hd__nand2_1
X_0591_ _0132_ VSS VDD VDD _0000_ sky130_fd_sc_hd__inv_1
X_0594_ j[1] j[0] VSS VDD VDD _0135_ sky130_fd_sc_hd__nand2b_1
X_0595_ j[2] j[3] j[4] _0135_ VSS VDD VDD _0136_ sky130_fd_sc_hd__nor4_1
X_0596_ state[2] _0136_ VSS VDD VDD _0001_ sky130_fd_sc_hd__and2_1
X_0598_ _0136_ state[2] VSS VDD VDD _0138_ sky130_fd_sc_hd__nand2b_1
X_0599_ net6 _0138_ VSS VDD VDD _0004_ sky130_fd_sc_hd__nand2b_1
X_0601_ mm_phase VSS VDD VDD _0140_ sky130_fd_sc_hd__clkinv_1
X_0603_ _0140_ exp_r[15] state[5] VSS VDD VDD _0003_ sky130_fd_sc_hd__a21boi_0
X_0605_ state[1] VSS VDD VDD _0143_ sky130_fd_sc_hd__inv_1
X_0606_ state[5] _0140_ exp_r[15] start state[0] VSS VDD VDD _0144_ sky130_fd_sc_hd__a32oi_1
X_0607_ _0143_ _0131_ _0144_ VSS VDD VDD _0005_ sky130_fd_sc_hd__o21ai_0
X_0608_ start state[0] VSS VDD VDD _0145_ sky130_fd_sc_hd__nand2b_1
X_0609_ state[4] _0145_ VSS VDD VDD _0002_ sky130_fd_sc_hd__nand2b_1
X_0611_ state[2] net6 VSS VDD VDD _0147_ sky130_fd_sc_hd__nor2_1
X_0613_ state[2] net6 VSS VDD VDD _0149_ sky130_fd_sc_hd__nor2b_1
X_0615_ state[2] mm_a[6] net4 mm_a[7] _0149_ result[7] VSS VDD VDD _0151_ sky130_fd_sc_hd__a222oi_1
X_0616_ _0151_ VSS VDD VDD _0006_ sky130_fd_sc_hd__inv_1
X_0618_ state[2] mm_a[5] net4 mm_a[6] _0149_ result[6] VSS VDD VDD _0153_ sky130_fd_sc_hd__a222oi_1
X_0619_ _0153_ VSS VDD VDD _0007_ sky130_fd_sc_hd__inv_1
X_0620_ state[2] mm_a[4] net4 mm_a[5] _0149_ result[5] VSS VDD VDD _0154_ sky130_fd_sc_hd__a222oi_1
X_0621_ _0154_ VSS VDD VDD _0008_ sky130_fd_sc_hd__inv_1
X_0622_ state[2] mm_a[3] net4 mm_a[4] _0149_ result[4] VSS VDD VDD _0155_ sky130_fd_sc_hd__a222oi_1
X_0623_ _0155_ VSS VDD VDD _0009_ sky130_fd_sc_hd__inv_1
X_0624_ state[2] mm_a[2] net4 mm_a[3] _0149_ result[3] VSS VDD VDD _0156_ sky130_fd_sc_hd__a222oi_1
X_0625_ _0156_ VSS VDD VDD _0010_ sky130_fd_sc_hd__inv_1
X_0626_ state[2] mm_a[1] net4 mm_a[2] _0149_ result[2] VSS VDD VDD _0157_ sky130_fd_sc_hd__a222oi_1
X_0627_ _0157_ VSS VDD VDD _0011_ sky130_fd_sc_hd__inv_1
X_0628_ state[2] mm_a[0] net4 mm_a[1] _0149_ result[1] VSS VDD VDD _0158_ sky130_fd_sc_hd__a222oi_1
X_0629_ _0158_ VSS VDD VDD _0012_ sky130_fd_sc_hd__inv_1
X_0630_ result[0] VSS VDD VDD _0159_ sky130_fd_sc_hd__inv_1
X_0631_ state[2] net6 VSS VDD VDD _0160_ sky130_fd_sc_hd__nand2b_1
X_0633_ mm_a[0] net4 VSS VDD VDD _0162_ sky130_fd_sc_hd__nand2_1
X_0634_ _0159_ _0160_ _0162_ VSS VDD VDD _0013_ sky130_fd_sc_hd__o21ai_0
X_0635_ j[0] j[1] j[2] VSS VDD VDD _0163_ sky130_fd_sc_hd__nor3_1
X_0636_ j[3] _0163_ state[2] VSS VDD VDD _0164_ sky130_fd_sc_hd__nand3b_1
X_0638_ state[2] _0163_ VSS VDD VDD _0166_ sky130_fd_sc_hd__nand2_1
X_0639_ j[3] _0160_ _0166_ VSS VDD VDD _0167_ sky130_fd_sc_hd__nand3_1
X_0640_ _0164_ _0167_ VSS VDD VDD _0014_ sky130_fd_sc_hd__nand2_1
X_0641_ j[0] j[1] _0138_ _0160_ j[2] VSS VDD VDD _0168_ sky130_fd_sc_hd__o311ai_0
X_0642_ _0166_ _0168_ VSS VDD VDD _0015_ sky130_fd_sc_hd__nand2_1
X_0643_ j[0] j[1] VSS VDD VDD _0169_ sky130_fd_sc_hd__nand2b_1
X_0644_ state[2] _0135_ _0169_ net4 j[1] VSS VDD VDD _0016_ sky130_fd_sc_hd__a32o_1
X_0645_ _0138_ _0160_ VSS VDD VDD _0170_ sky130_fd_sc_hd__nand2_1
X_0646_ state[2] j[0] VSS VDD VDD _0171_ sky130_fd_sc_hd__nor2_1
X_0647_ j[0] _0170_ _0171_ VSS VDD VDD _0017_ sky130_fd_sc_hd__a21oi_1
X_0651_ mm_p[12] mm_a[15] mm_b[13] VSS VDD VDD _0175_ sky130_fd_sc_hd__nand3_1
X_0652_ mm_a[15] mm_b[13] mm_p[12] VSS VDD VDD _0176_ sky130_fd_sc_hd__a21o_1
X_0653_ _0175_ _0176_ VSS VDD VDD _0177_ sky130_fd_sc_hd__nand2_1
X_0654_ mm_a[15] mm_b[12] mm_p[11] VSS VDD VDD _0178_ sky130_fd_sc_hd__a21oi_1
X_0655_ mm_p[10] mm_a[15] mm_b[11] VSS VDD VDD _0179_ sky130_fd_sc_hd__and3_1
X_0656_ mm_a[15] mm_b[11] mm_p[10] VSS VDD VDD _0180_ sky130_fd_sc_hd__a21oi_1
X_0657_ _0179_ _0180_ VSS VDD VDD _0181_ sky130_fd_sc_hd__nor2_1
X_0658_ mm_a[15] mm_b[10] VSS VDD VDD _0182_ sky130_fd_sc_hd__nand2_1
X_0659_ _0182_ VSS VDD VDD _0183_ sky130_fd_sc_hd__inv_1
X_0660_ mm_a[15] mm_b[9] VSS VDD VDD _0184_ sky130_fd_sc_hd__nand2_1
X_0661_ _0184_ VSS VDD VDD _0185_ sky130_fd_sc_hd__inv_1
X_0662_ mm_a[15] mm_b[8] VSS VDD VDD _0186_ sky130_fd_sc_hd__nand2_1
X_0663_ _0186_ VSS VDD VDD _0187_ sky130_fd_sc_hd__inv_1
X_0664_ mm_p[6] mm_a[15] mm_b[7] VSS VDD VDD _0188_ sky130_fd_sc_hd__and3_1
X_0665_ mm_a[15] mm_b[7] mm_p[6] VSS VDD VDD _0189_ sky130_fd_sc_hd__a21oi_1
X_0666_ _0188_ _0189_ VSS VDD VDD _0190_ sky130_fd_sc_hd__nor2_1
X_0667_ mm_a[15] mm_b[6] mm_p[5] VSS VDD VDD _0191_ sky130_fd_sc_hd__a21oi_1
X_0668_ _0191_ VSS VDD VDD _0192_ sky130_fd_sc_hd__inv_1
X_0669_ mm_p[4] mm_a[15] mm_b[5] VSS VDD VDD _0193_ sky130_fd_sc_hd__and3_1
X_0670_ mm_a[15] mm_b[5] mm_p[4] VSS VDD VDD _0194_ sky130_fd_sc_hd__a21oi_1
X_0671_ _0193_ _0194_ VSS VDD VDD _0195_ sky130_fd_sc_hd__nor2_1
X_0672_ mm_a[15] mm_b[4] mm_p[3] VSS VDD VDD _0196_ sky130_fd_sc_hd__a21o_1
X_0673_ mm_p[0] mm_a[15] mm_b[1] VSS VDD VDD _0197_ sky130_fd_sc_hd__nand3_1
X_0674_ mm_a[15] mm_b[2] mm_p[1] VSS VDD VDD _0198_ sky130_fd_sc_hd__a21oi_1
X_0675_ mm_p[1] mm_a[15] mm_b[2] VSS VDD VDD _0199_ sky130_fd_sc_hd__nand3_1
X_0676_ _0197_ _0198_ _0199_ VSS VDD VDD _0200_ sky130_fd_sc_hd__o21ai_1
X_0677_ mm_p[2] mm_a[15] mm_b[3] VSS VDD VDD _0201_ sky130_fd_sc_hd__and3_1
X_0678_ mm_a[15] mm_b[3] mm_p[2] VSS VDD VDD _0202_ sky130_fd_sc_hd__a21oi_1
X_0679_ _0201_ _0202_ VSS VDD VDD _0203_ sky130_fd_sc_hd__nor2_1
X_0680_ mm_p[3] mm_a[15] mm_b[4] VSS VDD VDD _0204_ sky130_fd_sc_hd__and3_1
X_0681_ _0200_ _0203_ _0204_ _0201_ VSS VDD VDD _0205_ sky130_fd_sc_hd__a211o_1
X_0682_ mm_p[5] mm_a[15] mm_b[6] VSS VDD VDD _0206_ sky130_fd_sc_hd__and3_1
X_0683_ _0195_ _0196_ _0205_ _0193_ _0206_ VSS VDD VDD _0207_ sky130_fd_sc_hd__a311o_1
X_0684_ _0190_ _0192_ _0207_ _0188_ VSS VDD VDD _0208_ sky130_fd_sc_hd__a31o_1
X_0685_ mm_p[7] _0187_ _0208_ VSS VDD VDD _0209_ sky130_fd_sc_hd__maj3_2
X_0686_ mm_p[8] _0185_ _0209_ VSS VDD VDD _0210_ sky130_fd_sc_hd__maj3_2
X_0687_ mm_p[9] _0183_ _0210_ VSS VDD VDD _0211_ sky130_fd_sc_hd__maj3_2
X_0688_ mm_p[11] mm_a[15] mm_b[12] VSS VDD VDD _0212_ sky130_fd_sc_hd__and3_1
X_0689_ _0181_ _0211_ _0212_ _0179_ VSS VDD VDD _0213_ sky130_fd_sc_hd__a211oi_2
X_0690_ _0177_ _0178_ _0213_ _0175_ VSS VDD VDD _0214_ sky130_fd_sc_hd__o31ai_1
X_0691_ mm_p[13] mm_b[14] mm_a[15] VSS VDD VDD _0215_ sky130_fd_sc_hd__and3_1
X_0692_ mm_b[14] mm_a[15] mm_p[13] VSS VDD VDD _0216_ sky130_fd_sc_hd__a21o_1
X_0693_ _0215_ _0216_ VSS VDD VDD _0217_ sky130_fd_sc_hd__nor2b_1
X_0694_ _0214_ _0217_ VSS VDD VDD _0218_ sky130_fd_sc_hd__xnor2_2
X_0695_ mod_r[13] _0218_ VSS VDD VDD _0219_ sky130_fd_sc_hd__or2_2
X_0696_ _0178_ _0213_ VSS VDD VDD _0220_ sky130_fd_sc_hd__nor2_1
X_0697_ _0177_ _0220_ VSS VDD VDD _0221_ sky130_fd_sc_hd__xor2_1
X_0698_ mod_r[12] _0221_ VSS VDD VDD _0222_ sky130_fd_sc_hd__nor2_1
X_0699_ _0181_ _0211_ _0179_ VSS VDD VDD _0223_ sky130_fd_sc_hd__a21oi_2
X_0700_ _0178_ _0212_ VSS VDD VDD _0224_ sky130_fd_sc_hd__nor2_1
X_0701_ _0223_ _0224_ VSS VDD VDD _0225_ sky130_fd_sc_hd__xor2_2
X_0702_ mod_r[11] _0225_ VSS VDD VDD _0226_ sky130_fd_sc_hd__nor2_1
X_0703_ _0181_ _0211_ VSS VDD VDD _0227_ sky130_fd_sc_hd__xnor2_1
X_0704_ mod_r[10] _0227_ VSS VDD VDD _0228_ sky130_fd_sc_hd__or2_2
X_0705_ mm_p[9] _0182_ VSS VDD VDD _0229_ sky130_fd_sc_hd__xor2_1
X_0706_ _0229_ _0210_ VSS VDD VDD _0230_ sky130_fd_sc_hd__xor2_1
X_0707_ mod_r[9] _0230_ VSS VDD VDD _0231_ sky130_fd_sc_hd__nor2_1
X_0708_ mm_p[8] _0184_ VSS VDD VDD _0232_ sky130_fd_sc_hd__xnor2_1
X_0709_ _0232_ _0209_ VSS VDD VDD _0233_ sky130_fd_sc_hd__xnor2_1
X_0710_ mod_r[8] _0233_ VSS VDD VDD _0234_ sky130_fd_sc_hd__nor2_1
X_0711_ mm_p[7] _0186_ VSS VDD VDD _0235_ sky130_fd_sc_hd__xnor2_1
X_0712_ _0235_ _0208_ VSS VDD VDD _0236_ sky130_fd_sc_hd__xnor2_1
X_0713_ mod_r[7] _0236_ VSS VDD VDD _0237_ sky130_fd_sc_hd__nor2_1
X_0714_ _0237_ VSS VDD VDD _0238_ sky130_fd_sc_hd__inv_1
X_0715_ _0192_ _0207_ VSS VDD VDD _0239_ sky130_fd_sc_hd__nand2_1
X_0716_ _0190_ _0239_ VSS VDD VDD _0240_ sky130_fd_sc_hd__xor2_1
X_0717_ mod_r[6] _0240_ VSS VDD VDD _0241_ sky130_fd_sc_hd__or2_2
X_0718_ _0195_ _0196_ _0205_ _0193_ VSS VDD VDD _0242_ sky130_fd_sc_hd__a31oi_1
X_0719_ _0206_ _0191_ VSS VDD VDD _0243_ sky130_fd_sc_hd__nor2_1
X_0720_ _0242_ _0243_ VSS VDD VDD _0244_ sky130_fd_sc_hd__xnor2_1
X_0721_ mod_r[5] _0244_ VSS VDD VDD _0245_ sky130_fd_sc_hd__nand2b_1
X_0722_ _0195_ _0196_ _0205_ VSS VDD VDD _0246_ sky130_fd_sc_hd__and3_1
X_0723_ _0196_ _0205_ _0195_ VSS VDD VDD _0247_ sky130_fd_sc_hd__a21oi_1
X_0724_ _0246_ _0247_ VSS VDD VDD _0248_ sky130_fd_sc_hd__or2_2
X_0725_ _0200_ _0203_ _0201_ VSS VDD VDD _0249_ sky130_fd_sc_hd__a21o_1
X_0726_ _0204_ _0196_ VSS VDD VDD _0250_ sky130_fd_sc_hd__nor2b_1
X_0727_ _0249_ _0250_ VSS VDD VDD _0251_ sky130_fd_sc_hd__xnor2_1
X_0728_ _0200_ _0203_ VSS VDD VDD _0252_ sky130_fd_sc_hd__xnor2_1
X_0729_ mm_a[15] mm_b[2] VSS VDD VDD _0253_ sky130_fd_sc_hd__nand2_1
X_0730_ mm_p[1] _0253_ _0197_ VSS VDD VDD _0254_ sky130_fd_sc_hd__xnor3_1
X_0731_ mm_a[15] mm_b[1] mm_p[0] VSS VDD VDD _0255_ sky130_fd_sc_hd__a21o_1
X_0732_ _0197_ _0255_ mod_r[0] VSS VDD VDD _0256_ sky130_fd_sc_hd__a21boi_0
X_0733_ mod_r[1] _0254_ _0256_ VSS VDD VDD _0257_ sky130_fd_sc_hd__maj3_2
X_0734_ mod_r[2] _0252_ _0257_ VSS VDD VDD _0258_ sky130_fd_sc_hd__maj3_2
X_0735_ mod_r[3] _0251_ _0258_ VSS VDD VDD _0259_ sky130_fd_sc_hd__maj3_1
X_0736_ mod_r[4] _0248_ _0259_ VSS VDD VDD _0260_ sky130_fd_sc_hd__maj3_2
X_0737_ _0244_ mod_r[5] VSS VDD VDD _0261_ sky130_fd_sc_hd__nor2b_1
X_0738_ mod_r[6] _0190_ _0239_ VSS VDD VDD _0262_ sky130_fd_sc_hd__xnor3_1
X_0739_ _0245_ _0260_ _0261_ _0262_ VSS VDD VDD _0263_ sky130_fd_sc_hd__a211o_1
X_0740_ mod_r[7] _0236_ VSS VDD VDD _0264_ sky130_fd_sc_hd__xnor2_1
X_0741_ _0241_ _0263_ _0264_ VSS VDD VDD _0265_ sky130_fd_sc_hd__a21o_1
X_0742_ mod_r[8] _0233_ VSS VDD VDD _0266_ sky130_fd_sc_hd__xnor2_1
X_0743_ _0238_ _0265_ _0266_ VSS VDD VDD _0267_ sky130_fd_sc_hd__a21oi_1
X_0744_ mod_r[9] _0230_ VSS VDD VDD _0268_ sky130_fd_sc_hd__nand2_1
X_0745_ mod_r[9] _0230_ VSS VDD VDD _0269_ sky130_fd_sc_hd__or2_2
X_0746_ _0234_ _0267_ _0268_ _0269_ VSS VDD VDD _0270_ sky130_fd_sc_hd__o211a_1
X_0747_ mod_r[10] _0227_ VSS VDD VDD _0271_ sky130_fd_sc_hd__nand2_1
X_0748_ _0231_ _0270_ _0271_ _0228_ VSS VDD VDD _0272_ sky130_fd_sc_hd__o211ai_1
X_0749_ mod_r[11] _0225_ VSS VDD VDD _0273_ sky130_fd_sc_hd__xnor2_1
X_0750_ _0228_ _0272_ _0273_ VSS VDD VDD _0274_ sky130_fd_sc_hd__a21oi_2
X_0751_ mod_r[12] _0221_ VSS VDD VDD _0275_ sky130_fd_sc_hd__xor2_1
X_0752_ _0226_ _0274_ _0275_ VSS VDD VDD _0276_ sky130_fd_sc_hd__o21a_1
X_0753_ mod_r[13] _0218_ VSS VDD VDD _0277_ sky130_fd_sc_hd__xor2_1
X_0754_ _0222_ _0276_ _0277_ VSS VDD VDD _0278_ sky130_fd_sc_hd__o21ai_2
X_0755_ mm_p[14] mm_a[15] mm_b[15] VSS VDD VDD _0279_ sky130_fd_sc_hd__nand3_1
X_0756_ mm_a[15] mm_b[15] mm_p[14] VSS VDD VDD _0280_ sky130_fd_sc_hd__a21o_1
X_0757_ _0279_ _0280_ VSS VDD VDD _0281_ sky130_fd_sc_hd__nand2_1
X_0758_ _0215_ _0214_ _0216_ VSS VDD VDD _0282_ sky130_fd_sc_hd__o21ai_2
X_0759_ _0281_ _0282_ VSS VDD VDD _0283_ sky130_fd_sc_hd__xnor2_1
X_0760_ mod_r[14] _0283_ VSS VDD VDD _0284_ sky130_fd_sc_hd__xnor2_1
X_0761_ _0219_ _0278_ _0284_ VSS VDD VDD _0285_ sky130_fd_sc_hd__a21oi_2
X_0762_ _0281_ _0282_ _0279_ VSS VDD VDD _0286_ sky130_fd_sc_hd__o21ai_0
X_0763_ mm_p[15] _0286_ VSS VDD VDD _0287_ sky130_fd_sc_hd__nor2_1
X_0764_ mod_r[15] _0287_ VSS VDD VDD _0288_ sky130_fd_sc_hd__nor2_1
X_0765_ mm_p[15] _0286_ VSS VDD VDD _0289_ sky130_fd_sc_hd__nand2_1
X_0766_ mod_r[14] _0283_ _0289_ VSS VDD VDD _0290_ sky130_fd_sc_hd__o21ai_0
X_0767_ mod_r[15] _0287_ VSS VDD VDD _0291_ sky130_fd_sc_hd__nand2_1
X_0768_ _0285_ _0288_ _0290_ _0291_ VSS VDD VDD _0292_ sky130_fd_sc_hd__o31a_4
X_0770_ mod_r[13] _0221_ VSS VDD VDD _0294_ sky130_fd_sc_hd__or2_2
X_0771_ mod_r[12] _0225_ VSS VDD VDD _0295_ sky130_fd_sc_hd__nor2_1
X_0772_ mod_r[11] _0227_ VSS VDD VDD _0296_ sky130_fd_sc_hd__nor2_1
X_0773_ mod_r[10] _0230_ VSS VDD VDD _0297_ sky130_fd_sc_hd__nor2_1
X_0774_ mod_r[9] _0233_ VSS VDD VDD _0298_ sky130_fd_sc_hd__or2_2
X_0775_ mod_r[8] _0236_ VSS VDD VDD _0299_ sky130_fd_sc_hd__nor2_1
X_0776_ _0299_ VSS VDD VDD _0300_ sky130_fd_sc_hd__inv_1
X_0777_ mod_r[7] _0240_ VSS VDD VDD _0301_ sky130_fd_sc_hd__nor2_1
X_0778_ mod_r[6] _0244_ VSS VDD VDD _0302_ sky130_fd_sc_hd__nand2b_1
X_0779_ mod_r[5] _0246_ _0247_ VSS VDD VDD _0303_ sky130_fd_sc_hd__nor3_1
X_0780_ mod_r[4] _0251_ VSS VDD VDD _0304_ sky130_fd_sc_hd__nor2_1
X_0781_ mod_r[3] _0252_ VSS VDD VDD _0305_ sky130_fd_sc_hd__nor2_1
X_0782_ mod_r[2] _0254_ VSS VDD VDD _0306_ sky130_fd_sc_hd__nor2_1
X_0783_ _0197_ _0255_ VSS VDD VDD _0307_ sky130_fd_sc_hd__nand2_1
X_0784_ mm_a[15] mm_b[0] VSS VDD VDD _0308_ sky130_fd_sc_hd__nand2_1
X_0785_ mod_r[0] _0308_ VSS VDD VDD _0309_ sky130_fd_sc_hd__and2_1
X_0786_ mod_r[1] _0307_ _0309_ VSS VDD VDD _0310_ sky130_fd_sc_hd__maj3_1
X_0787_ mod_r[2] _0254_ VSS VDD VDD _0311_ sky130_fd_sc_hd__xor2_1
X_0788_ _0310_ _0311_ VSS VDD VDD _0312_ sky130_fd_sc_hd__nor2b_1
X_0789_ mod_r[3] _0252_ VSS VDD VDD _0313_ sky130_fd_sc_hd__nand2_1
X_0790_ mod_r[4] _0249_ _0250_ VSS VDD VDD _0314_ sky130_fd_sc_hd__xnor3_1
X_0791_ _0305_ _0306_ _0312_ _0313_ _0314_ VSS VDD VDD _0315_ sky130_fd_sc_hd__o311a_1
X_0792_ _0246_ _0247_ mod_r[5] VSS VDD VDD _0316_ sky130_fd_sc_hd__o21ai_0
X_0793_ mod_r[6] _0242_ _0243_ VSS VDD VDD _0317_ sky130_fd_sc_hd__xor3_1
X_0794_ _0303_ _0304_ _0315_ _0316_ _0317_ VSS VDD VDD _0318_ sky130_fd_sc_hd__o311ai_0
X_0795_ mod_r[7] _0190_ _0239_ VSS VDD VDD _0319_ sky130_fd_sc_hd__xnor3_1
X_0796_ _0302_ _0318_ _0319_ VSS VDD VDD _0320_ sky130_fd_sc_hd__a21oi_1
X_0797_ mod_r[8] _0236_ VSS VDD VDD _0321_ sky130_fd_sc_hd__xnor2_1
X_0798_ _0301_ _0320_ _0321_ VSS VDD VDD _0322_ sky130_fd_sc_hd__o21bai_1
X_0799_ mod_r[9] _0233_ VSS VDD VDD _0323_ sky130_fd_sc_hd__and2_1
X_0800_ mod_r[10] _0229_ _0210_ VSS VDD VDD _0324_ sky130_fd_sc_hd__xnor3_1
X_0801_ _0298_ _0300_ _0322_ _0323_ _0324_ VSS VDD VDD _0325_ sky130_fd_sc_hd__a311oi_1
X_0802_ mod_r[11] _0181_ _0211_ VSS VDD VDD _0326_ sky130_fd_sc_hd__xnor3_1
X_0803_ _0297_ _0325_ _0326_ VSS VDD VDD _0327_ sky130_fd_sc_hd__o21a_1
X_0804_ mod_r[12] _0223_ _0224_ VSS VDD VDD _0328_ sky130_fd_sc_hd__xor3_1
X_0805_ _0296_ _0327_ _0328_ VSS VDD VDD _0329_ sky130_fd_sc_hd__o21a_1
X_0806_ mod_r[13] _0177_ _0220_ VSS VDD VDD _0330_ sky130_fd_sc_hd__xnor3_1
X_0807_ _0295_ _0329_ _0330_ VSS VDD VDD _0331_ sky130_fd_sc_hd__o21bai_1
X_0808_ mod_r[14] _0218_ VSS VDD VDD _0332_ sky130_fd_sc_hd__xnor2_1
X_0809_ _0294_ _0331_ _0332_ VSS VDD VDD _0333_ sky130_fd_sc_hd__a21oi_2
X_0810_ _0294_ _0331_ _0332_ VSS VDD VDD _0334_ sky130_fd_sc_hd__nand3_1
X_0811_ _0333_ _0334_ VSS VDD VDD _0335_ sky130_fd_sc_hd__nand2b_1
X_0812_ mod_r[14] _0218_ VSS VDD VDD _0336_ sky130_fd_sc_hd__nor2_1
X_0813_ _0336_ _0333_ VSS VDD VDD _0337_ sky130_fd_sc_hd__nor2_1
X_0814_ mod_r[15] _0283_ VSS VDD VDD _0338_ sky130_fd_sc_hd__xnor2_1
X_0815_ _0281_ _0282_ _0287_ VSS VDD VDD _0339_ sky130_fd_sc_hd__and3_1
X_0816_ mod_r[15] _0287_ VSS VDD VDD _0340_ sky130_fd_sc_hd__and2_1
X_0817_ _0337_ _0338_ _0339_ _0340_ VSS VDD VDD _0341_ sky130_fd_sc_hd__o22ai_4
X_0819_ _0218_ _0335_ _0341_ VSS VDD VDD _0343_ sky130_fd_sc_hd__mux2i_1
X_0820_ _0292_ _0343_ VSS VDD VDD _0344_ sky130_fd_sc_hd__nor2_1
X_0821_ _0285_ _0288_ _0290_ _0291_ VSS VDD VDD _0345_ sky130_fd_sc_hd__o31ai_4
X_0823_ _0222_ _0276_ VSS VDD VDD _0347_ sky130_fd_sc_hd__nor2_1
X_0824_ _0347_ _0277_ VSS VDD VDD _0348_ sky130_fd_sc_hd__xnor2_1
X_0825_ _0345_ _0348_ state[2] VSS VDD VDD _0349_ sky130_fd_sc_hd__o21ai_0
X_0826_ mm_p[14] net4 VSS VDD VDD _0350_ sky130_fd_sc_hd__nand2_1
X_0827_ _0344_ _0349_ _0350_ VSS VDD VDD _0018_ sky130_fd_sc_hd__o21ai_1
X_0828_ _0295_ _0329_ VSS VDD VDD _0351_ sky130_fd_sc_hd__or2_2
X_0829_ _0351_ _0330_ VSS VDD VDD _0352_ sky130_fd_sc_hd__xor2_1
X_0830_ _0221_ _0352_ _0341_ VSS VDD VDD _0353_ sky130_fd_sc_hd__mux2i_1
X_0831_ _0292_ _0353_ VSS VDD VDD _0354_ sky130_fd_sc_hd__nor2_1
X_0832_ _0226_ _0274_ _0275_ VSS VDD VDD _0355_ sky130_fd_sc_hd__nor3_1
X_0833_ _0276_ _0355_ VSS VDD VDD _0356_ sky130_fd_sc_hd__nor2_1
X_0834_ _0345_ _0356_ state[2] VSS VDD VDD _0357_ sky130_fd_sc_hd__o21ai_0
X_0835_ mm_p[13] net4 VSS VDD VDD _0358_ sky130_fd_sc_hd__nand2_1
X_0836_ _0354_ _0357_ _0358_ VSS VDD VDD _0019_ sky130_fd_sc_hd__o21ai_1
X_0838_ _0296_ _0327_ _0328_ VSS VDD VDD _0360_ sky130_fd_sc_hd__or3_1
X_0839_ _0329_ _0341_ _0360_ VSS VDD VDD _0361_ sky130_fd_sc_hd__nand3b_1
X_0840_ _0225_ _0341_ _0361_ _0345_ VSS VDD VDD _0362_ sky130_fd_sc_hd__o211ai_1
X_0841_ _0228_ _0272_ _0273_ VSS VDD VDD _0363_ sky130_fd_sc_hd__nand3_1
X_0842_ _0274_ _0363_ VSS VDD VDD _0364_ sky130_fd_sc_hd__nand2b_1
X_0843_ _0292_ _0364_ VSS VDD VDD _0365_ sky130_fd_sc_hd__nand2_1
X_0844_ state[2] _0362_ _0365_ net4 mm_p[12] VSS VDD VDD _0020_ sky130_fd_sc_hd__a32o_1
X_0845_ _0297_ _0325_ _0326_ VSS VDD VDD _0366_ sky130_fd_sc_hd__nor3_1
X_0846_ _0327_ _0366_ VSS VDD VDD _0367_ sky130_fd_sc_hd__nor2_1
X_0847_ _0227_ _0341_ VSS VDD VDD _0368_ sky130_fd_sc_hd__nor2_1
X_0848_ _0341_ _0367_ _0368_ _0292_ VSS VDD VDD _0369_ sky130_fd_sc_hd__a211oi_1
X_0849_ _0231_ _0270_ VSS VDD VDD _0370_ sky130_fd_sc_hd__nor2_1
X_0850_ mod_r[10] _0227_ _0370_ VSS VDD VDD _0371_ sky130_fd_sc_hd__xnor3_1
X_0851_ _0345_ _0371_ state[2] VSS VDD VDD _0372_ sky130_fd_sc_hd__o21ai_0
X_0852_ mm_p[11] net4 VSS VDD VDD _0373_ sky130_fd_sc_hd__nand2_1
X_0853_ _0369_ _0372_ _0373_ VSS VDD VDD _0021_ sky130_fd_sc_hd__o21ai_1
X_0854_ _0300_ _0322_ VSS VDD VDD _0374_ sky130_fd_sc_hd__and2_1
X_0855_ _0298_ _0374_ _0323_ VSS VDD VDD _0375_ sky130_fd_sc_hd__a21oi_1
X_0856_ _0324_ _0375_ VSS VDD VDD _0376_ sky130_fd_sc_hd__xnor2_1
X_0857_ _0341_ _0376_ VSS VDD VDD _0377_ sky130_fd_sc_hd__nand2_1
X_0858_ _0230_ _0341_ _0377_ _0345_ VSS VDD VDD _0378_ sky130_fd_sc_hd__o211ai_1
X_0859_ _0234_ _0267_ VSS VDD VDD _0379_ sky130_fd_sc_hd__nor2_1
X_0860_ mod_r[9] _0230_ _0379_ VSS VDD VDD _0380_ sky130_fd_sc_hd__xor3_1
X_0861_ _0292_ _0380_ VSS VDD VDD _0381_ sky130_fd_sc_hd__nand2_1
X_0862_ state[2] _0378_ _0381_ net4 mm_p[10] VSS VDD VDD _0022_ sky130_fd_sc_hd__a32o_1
X_0863_ _0238_ _0265_ _0266_ VSS VDD VDD _0382_ sky130_fd_sc_hd__nand3_1
X_0864_ _0267_ _0382_ VSS VDD VDD _0383_ sky130_fd_sc_hd__nand2b_1
X_0865_ _0292_ _0383_ VSS VDD VDD _0384_ sky130_fd_sc_hd__nand2_1
X_0866_ mod_r[9] _0233_ VSS VDD VDD _0385_ sky130_fd_sc_hd__nand2_1
X_0867_ _0298_ _0385_ VSS VDD VDD _0386_ sky130_fd_sc_hd__nand2_1
X_0868_ _0374_ _0386_ VSS VDD VDD _0387_ sky130_fd_sc_hd__xnor2_1
X_0869_ _0387_ _0341_ VSS VDD VDD _0388_ sky130_fd_sc_hd__nand2b_1
X_0870_ _0233_ _0341_ _0388_ _0345_ VSS VDD VDD _0389_ sky130_fd_sc_hd__o211ai_1
X_0871_ state[2] _0384_ _0389_ net4 mm_p[9] VSS VDD VDD _0023_ sky130_fd_sc_hd__a32o_1
X_0872_ _0301_ _0320_ VSS VDD VDD _0390_ sky130_fd_sc_hd__nor2_1
X_0873_ _0390_ _0321_ VSS VDD VDD _0391_ sky130_fd_sc_hd__nand2_1
X_0874_ _0236_ _0341_ VSS VDD VDD _0392_ sky130_fd_sc_hd__nor2_1
X_0875_ _0322_ _0341_ _0391_ _0392_ _0292_ VSS VDD VDD _0393_ sky130_fd_sc_hd__a311oi_1
X_0876_ _0241_ _0263_ VSS VDD VDD _0394_ sky130_fd_sc_hd__and2_1
X_0877_ _0394_ _0264_ VSS VDD VDD _0395_ sky130_fd_sc_hd__xor2_1
X_0878_ _0345_ _0395_ state[2] VSS VDD VDD _0396_ sky130_fd_sc_hd__o21ai_0
X_0879_ mm_p[8] net4 VSS VDD VDD _0397_ sky130_fd_sc_hd__nand2_1
X_0880_ _0393_ _0396_ _0397_ VSS VDD VDD _0024_ sky130_fd_sc_hd__o21ai_1
X_0881_ _0302_ _0318_ _0319_ VSS VDD VDD _0398_ sky130_fd_sc_hd__nand3_1
X_0882_ _0320_ _0341_ _0398_ VSS VDD VDD _0399_ sky130_fd_sc_hd__nand3b_1
X_0883_ _0240_ _0341_ _0399_ _0345_ VSS VDD VDD _0400_ sky130_fd_sc_hd__o211ai_1
X_0884_ _0245_ _0260_ _0261_ VSS VDD VDD _0401_ sky130_fd_sc_hd__a21oi_1
X_0885_ _0262_ _0401_ VSS VDD VDD _0402_ sky130_fd_sc_hd__xor2_1
X_0886_ _0292_ _0402_ VSS VDD VDD _0403_ sky130_fd_sc_hd__nand2_1
X_0887_ state[2] _0400_ _0403_ net4 mm_p[7] VSS VDD VDD _0025_ sky130_fd_sc_hd__a32o_1
X_0888_ _0304_ _0315_ VSS VDD VDD _0404_ sky130_fd_sc_hd__or2_2
X_0889_ _0303_ _0404_ _0316_ VSS VDD VDD _0405_ sky130_fd_sc_hd__o21ai_0
X_0890_ _0317_ _0405_ VSS VDD VDD _0406_ sky130_fd_sc_hd__xnor2_1
X_0891_ _0244_ _0406_ _0341_ VSS VDD VDD _0407_ sky130_fd_sc_hd__mux2i_1
X_0892_ _0345_ _0407_ VSS VDD VDD _0408_ sky130_fd_sc_hd__nand2_1
X_0893_ mod_r[5] _0244_ VSS VDD VDD _0409_ sky130_fd_sc_hd__xnor2_1
X_0894_ _0260_ _0409_ VSS VDD VDD _0410_ sky130_fd_sc_hd__xor2_1
X_0895_ _0292_ _0410_ VSS VDD VDD _0411_ sky130_fd_sc_hd__nand2_1
X_0896_ state[2] _0408_ _0411_ net4 mm_p[6] VSS VDD VDD _0026_ sky130_fd_sc_hd__a32o_1
X_0897_ mod_r[4] _0248_ VSS VDD VDD _0412_ sky130_fd_sc_hd__xor2_1
X_0898_ _0412_ _0259_ VSS VDD VDD _0413_ sky130_fd_sc_hd__xor2_1
X_0899_ _0292_ _0413_ VSS VDD VDD _0414_ sky130_fd_sc_hd__nand2_1
X_0900_ _0303_ _0316_ VSS VDD VDD _0415_ sky130_fd_sc_hd__nor2b_1
X_0901_ _0404_ _0415_ VSS VDD VDD _0416_ sky130_fd_sc_hd__xor2_1
X_0902_ _0341_ _0416_ VSS VDD VDD _0417_ sky130_fd_sc_hd__nand2_1
X_0903_ _0248_ _0341_ _0417_ _0345_ VSS VDD VDD _0418_ sky130_fd_sc_hd__o211ai_1
X_0904_ state[2] _0414_ _0418_ net4 mm_p[5] VSS VDD VDD _0027_ sky130_fd_sc_hd__a32o_1
X_0905_ _0305_ _0306_ _0312_ _0313_ VSS VDD VDD _0419_ sky130_fd_sc_hd__o31ai_1
X_0906_ _0314_ _0419_ VSS VDD VDD _0420_ sky130_fd_sc_hd__xnor2_1
X_0907_ _0251_ _0341_ VSS VDD VDD _0421_ sky130_fd_sc_hd__nor2_1
X_0908_ _0341_ _0420_ _0421_ _0292_ VSS VDD VDD _0422_ sky130_fd_sc_hd__a211oi_1
X_0909_ mod_r[3] _0251_ VSS VDD VDD _0423_ sky130_fd_sc_hd__xnor2_1
X_0910_ _0258_ _0423_ VSS VDD VDD _0424_ sky130_fd_sc_hd__xor2_1
X_0911_ _0345_ _0424_ state[2] VSS VDD VDD _0425_ sky130_fd_sc_hd__o21ai_0
X_0912_ mm_p[4] net4 VSS VDD VDD _0426_ sky130_fd_sc_hd__nand2_1
X_0913_ _0422_ _0425_ _0426_ VSS VDD VDD _0028_ sky130_fd_sc_hd__o21ai_1
X_0914_ mod_r[2] _0252_ VSS VDD VDD _0427_ sky130_fd_sc_hd__xnor2_1
X_0915_ _0257_ _0427_ VSS VDD VDD _0428_ sky130_fd_sc_hd__xnor2_1
X_0916_ _0292_ _0428_ VSS VDD VDD _0429_ sky130_fd_sc_hd__nand2_1
X_0917_ _0306_ _0312_ VSS VDD VDD _0430_ sky130_fd_sc_hd__nor2_1
X_0918_ _0305_ _0313_ VSS VDD VDD _0431_ sky130_fd_sc_hd__nand2b_1
X_0919_ _0430_ _0431_ VSS VDD VDD _0432_ sky130_fd_sc_hd__xor2_1
X_0920_ _0341_ _0432_ VSS VDD VDD _0433_ sky130_fd_sc_hd__nand2_1
X_0921_ _0252_ _0341_ _0433_ _0345_ VSS VDD VDD _0434_ sky130_fd_sc_hd__o211ai_1
X_0922_ state[2] _0429_ _0434_ net4 mm_p[3] VSS VDD VDD _0029_ sky130_fd_sc_hd__a32o_1
X_0923_ _0310_ _0311_ VSS VDD VDD _0435_ sky130_fd_sc_hd__xnor2_1
X_0924_ _0254_ _0341_ VSS VDD VDD _0436_ sky130_fd_sc_hd__nor2_1
X_0925_ _0341_ _0435_ _0436_ _0292_ VSS VDD VDD _0437_ sky130_fd_sc_hd__a211oi_1
X_0926_ mod_r[1] _0254_ VSS VDD VDD _0438_ sky130_fd_sc_hd__xor2_1
X_0927_ _0256_ _0438_ VSS VDD VDD _0439_ sky130_fd_sc_hd__xnor2_1
X_0928_ _0345_ _0439_ state[2] VSS VDD VDD _0440_ sky130_fd_sc_hd__o21ai_0
X_0929_ mm_p[2] net4 VSS VDD VDD _0441_ sky130_fd_sc_hd__nand2_1
X_0930_ _0437_ _0440_ _0441_ VSS VDD VDD _0030_ sky130_fd_sc_hd__o21ai_1
X_0931_ mod_r[0] _0307_ VSS VDD VDD _0442_ sky130_fd_sc_hd__nor2_1
X_0932_ _0256_ _0345_ _0442_ VSS VDD VDD _0443_ sky130_fd_sc_hd__nor3_1
X_0933_ mod_r[1] _0307_ VSS VDD VDD _0444_ sky130_fd_sc_hd__xnor2_1
X_0934_ _0309_ _0444_ VSS VDD VDD _0445_ sky130_fd_sc_hd__xnor2_1
X_0935_ _0307_ _0445_ _0341_ VSS VDD VDD _0446_ sky130_fd_sc_hd__mux2i_1
X_0936_ _0292_ _0446_ state[2] VSS VDD VDD _0447_ sky130_fd_sc_hd__o21ai_0
X_0937_ mm_p[1] net4 VSS VDD VDD _0448_ sky130_fd_sc_hd__nand2_1
X_0938_ _0443_ _0447_ _0448_ VSS VDD VDD _0031_ sky130_fd_sc_hd__o21ai_1
X_0939_ mod_r[0] _0341_ VSS VDD VDD _0449_ sky130_fd_sc_hd__nand2_1
X_0940_ _0292_ _0449_ _0308_ VSS VDD VDD _0450_ sky130_fd_sc_hd__o21a_1
X_0941_ _0292_ _0308_ _0449_ state[2] VSS VDD VDD _0451_ sky130_fd_sc_hd__o31ai_1
X_0942_ mm_p[0] net4 VSS VDD VDD _0452_ sky130_fd_sc_hd__nand2_1
X_0943_ _0450_ _0451_ _0452_ VSS VDD VDD _0032_ sky130_fd_sc_hd__o21ai_1
X_0944_ state[5] state[0] _0145_ VSS VDD VDD _0453_ sky130_fd_sc_hd__o21ai_1
X_0946_ state[5] _0145_ VSS VDD VDD _0455_ sky130_fd_sc_hd__and2_1
X_0949_ result[14] _0453_ _0455_ mm_p[14] VSS VDD VDD _0033_ sky130_fd_sc_hd__a22o_1
X_0950_ result[13] _0453_ _0455_ mm_p[13] VSS VDD VDD _0034_ sky130_fd_sc_hd__a22o_1
X_0951_ result[12] _0453_ _0455_ mm_p[12] VSS VDD VDD _0035_ sky130_fd_sc_hd__a22o_1
X_0952_ result[11] _0453_ _0455_ mm_p[11] VSS VDD VDD _0036_ sky130_fd_sc_hd__a22o_1
X_0953_ result[10] _0453_ _0455_ mm_p[10] VSS VDD VDD _0037_ sky130_fd_sc_hd__a22o_1
X_0954_ result[9] _0453_ _0455_ mm_p[9] VSS VDD VDD _0038_ sky130_fd_sc_hd__a22o_1
X_0955_ result[8] _0453_ _0455_ mm_p[8] VSS VDD VDD _0039_ sky130_fd_sc_hd__a22o_1
X_0956_ result[7] _0453_ _0455_ mm_p[7] VSS VDD VDD _0040_ sky130_fd_sc_hd__a22o_1
X_0957_ result[6] _0453_ _0455_ mm_p[6] VSS VDD VDD _0041_ sky130_fd_sc_hd__a22o_1
X_0958_ result[5] _0453_ _0455_ mm_p[5] VSS VDD VDD _0042_ sky130_fd_sc_hd__a22o_1
X_0959_ result[4] _0453_ _0455_ mm_p[4] VSS VDD VDD _0043_ sky130_fd_sc_hd__a22o_1
X_0960_ result[3] _0453_ _0455_ mm_p[3] VSS VDD VDD _0044_ sky130_fd_sc_hd__a22o_1
X_0961_ result[2] _0453_ _0455_ mm_p[2] VSS VDD VDD _0045_ sky130_fd_sc_hd__a22o_1
X_0962_ result[1] _0453_ _0455_ mm_p[1] VSS VDD VDD _0046_ sky130_fd_sc_hd__a22o_1
X_0963_ state[5] _0145_ VSS VDD VDD _0458_ sky130_fd_sc_hd__nand2_1
X_0964_ mm_p[0] _0458_ VSS VDD VDD _0459_ sky130_fd_sc_hd__nor2_1
X_0965_ _0159_ _0453_ _0459_ VSS VDD VDD _0047_ sky130_fd_sc_hd__a21oi_1
X_0966_ state[1] state[0] _0145_ VSS VDD VDD _0460_ sky130_fd_sc_hd__o21ai_1
X_0968_ exp_in[14] exp_r[13] state[1] VSS VDD VDD _0462_ sky130_fd_sc_hd__mux2i_1
X_0970_ exp_r[14] net3 VSS VDD VDD _0464_ sky130_fd_sc_hd__nand2_1
X_0971_ net3 _0462_ _0464_ VSS VDD VDD _0048_ sky130_fd_sc_hd__o21ai_0
X_0972_ exp_in[13] exp_r[12] state[1] VSS VDD VDD _0465_ sky130_fd_sc_hd__mux2i_1
X_0973_ exp_r[13] net3 VSS VDD VDD _0466_ sky130_fd_sc_hd__nand2_1
X_0974_ net3 _0465_ _0466_ VSS VDD VDD _0049_ sky130_fd_sc_hd__o21ai_0
X_0975_ exp_in[12] exp_r[11] state[1] VSS VDD VDD _0467_ sky130_fd_sc_hd__mux2i_1
X_0976_ exp_r[12] net3 VSS VDD VDD _0468_ sky130_fd_sc_hd__nand2_1
X_0977_ net3 _0467_ _0468_ VSS VDD VDD _0050_ sky130_fd_sc_hd__o21ai_0
X_0978_ exp_in[11] exp_r[10] state[1] VSS VDD VDD _0469_ sky130_fd_sc_hd__mux2i_1
X_0979_ exp_r[11] net3 VSS VDD VDD _0470_ sky130_fd_sc_hd__nand2_1
X_0980_ net3 _0469_ _0470_ VSS VDD VDD _0051_ sky130_fd_sc_hd__o21ai_0
X_0981_ state[0] start VSS VDD VDD _0471_ sky130_fd_sc_hd__nand2_1
X_0983_ base_in[14] base_r[14] net5 VSS VDD VDD _0052_ sky130_fd_sc_hd__mux2_2
X_0984_ base_in[13] base_r[13] net5 VSS VDD VDD _0053_ sky130_fd_sc_hd__mux2_2
X_0985_ base_in[12] base_r[12] net5 VSS VDD VDD _0054_ sky130_fd_sc_hd__mux2_2
X_0986_ base_in[11] base_r[11] net5 VSS VDD VDD _0055_ sky130_fd_sc_hd__mux2_2
X_0987_ base_in[10] base_r[10] net5 VSS VDD VDD _0056_ sky130_fd_sc_hd__mux2_2
X_0988_ base_in[9] base_r[9] net5 VSS VDD VDD _0057_ sky130_fd_sc_hd__mux2_2
X_0989_ base_in[8] base_r[8] net5 VSS VDD VDD _0058_ sky130_fd_sc_hd__mux2_2
X_0990_ base_in[7] base_r[7] net5 VSS VDD VDD _0059_ sky130_fd_sc_hd__mux2_2
X_0991_ base_in[6] base_r[6] net5 VSS VDD VDD _0060_ sky130_fd_sc_hd__mux2_2
X_0992_ base_in[5] base_r[5] net5 VSS VDD VDD _0061_ sky130_fd_sc_hd__mux2_2
X_0994_ base_in[4] base_r[4] net5 VSS VDD VDD _0062_ sky130_fd_sc_hd__mux2_2
X_0995_ base_in[3] base_r[3] net5 VSS VDD VDD _0063_ sky130_fd_sc_hd__mux2_2
X_0996_ base_in[2] base_r[2] net5 VSS VDD VDD _0064_ sky130_fd_sc_hd__mux2_2
X_0997_ base_in[1] base_r[1] net5 VSS VDD VDD _0065_ sky130_fd_sc_hd__mux2_2
X_0998_ base_in[0] base_r[0] net5 VSS VDD VDD _0066_ sky130_fd_sc_hd__mux2_2
X_0999_ mod_in[14] mod_r[14] net5 VSS VDD VDD _0067_ sky130_fd_sc_hd__mux2_2
X_1000_ mod_in[13] mod_r[13] net5 VSS VDD VDD _0068_ sky130_fd_sc_hd__mux2_2
X_1001_ mod_in[12] mod_r[12] net5 VSS VDD VDD _0069_ sky130_fd_sc_hd__mux2_2
X_1002_ mod_in[11] mod_r[11] net5 VSS VDD VDD _0070_ sky130_fd_sc_hd__mux2_2
X_1003_ mod_in[10] mod_r[10] net5 VSS VDD VDD _0071_ sky130_fd_sc_hd__mux2_2
X_1005_ mod_in[9] mod_r[9] net5 VSS VDD VDD _0072_ sky130_fd_sc_hd__mux2_2
X_1006_ mod_in[8] mod_r[8] net5 VSS VDD VDD _0073_ sky130_fd_sc_hd__mux2_2
X_1007_ mod_in[7] mod_r[7] net5 VSS VDD VDD _0074_ sky130_fd_sc_hd__mux2_2
X_1008_ mod_in[6] mod_r[6] net5 VSS VDD VDD _0075_ sky130_fd_sc_hd__mux2_2
X_1009_ mod_in[5] mod_r[5] net5 VSS VDD VDD _0076_ sky130_fd_sc_hd__mux2_2
X_1010_ mod_in[4] mod_r[4] net5 VSS VDD VDD _0077_ sky130_fd_sc_hd__mux2_2
X_1011_ mod_in[3] mod_r[3] net5 VSS VDD VDD _0078_ sky130_fd_sc_hd__mux2_2
X_1012_ mod_in[2] mod_r[2] net5 VSS VDD VDD _0079_ sky130_fd_sc_hd__mux2_2
X_1013_ mod_in[1] mod_r[1] net5 VSS VDD VDD _0080_ sky130_fd_sc_hd__mux2_2
X_1014_ mod_in[0] mod_r[0] net5 VSS VDD VDD _0081_ sky130_fd_sc_hd__mux2_2
X_1016_ result[14] _0140_ VSS VDD VDD _0476_ sky130_fd_sc_hd__nand2_1
X_1017_ base_r[14] mm_phase VSS VDD VDD _0477_ sky130_fd_sc_hd__nand2_1
X_1019_ mm_b[14] net6 VSS VDD VDD _0479_ sky130_fd_sc_hd__nor2_1
X_1020_ net6 _0476_ _0477_ _0479_ VSS VDD VDD _0082_ sky130_fd_sc_hd__a31oi_1
X_1021_ result[13] _0140_ VSS VDD VDD _0480_ sky130_fd_sc_hd__nand2_1
X_1023_ mm_phase base_r[13] VSS VDD VDD _0482_ sky130_fd_sc_hd__nand2_1
X_1025_ mm_b[13] net6 VSS VDD VDD _0484_ sky130_fd_sc_hd__nor2_1
X_1026_ net6 _0480_ _0482_ _0484_ VSS VDD VDD _0083_ sky130_fd_sc_hd__a31oi_1
X_1027_ result[12] _0140_ VSS VDD VDD _0485_ sky130_fd_sc_hd__nand2_1
X_1028_ mm_phase base_r[12] VSS VDD VDD _0486_ sky130_fd_sc_hd__nand2_1
X_1029_ mm_b[12] net6 VSS VDD VDD _0487_ sky130_fd_sc_hd__nor2_1
X_1030_ net6 _0485_ _0486_ _0487_ VSS VDD VDD _0084_ sky130_fd_sc_hd__a31oi_1
X_1031_ result[11] _0140_ VSS VDD VDD _0488_ sky130_fd_sc_hd__nand2_1
X_1032_ mm_phase base_r[11] VSS VDD VDD _0489_ sky130_fd_sc_hd__nand2_1
X_1033_ mm_b[11] net6 VSS VDD VDD _0490_ sky130_fd_sc_hd__nor2_1
X_1034_ net6 _0488_ _0489_ _0490_ VSS VDD VDD _0085_ sky130_fd_sc_hd__a31oi_1
X_1035_ result[10] _0140_ VSS VDD VDD _0491_ sky130_fd_sc_hd__nand2_1
X_1036_ mm_phase base_r[10] VSS VDD VDD _0492_ sky130_fd_sc_hd__nand2_1
X_1037_ mm_b[10] net6 VSS VDD VDD _0493_ sky130_fd_sc_hd__nor2_1
X_1038_ net6 _0491_ _0492_ _0493_ VSS VDD VDD _0086_ sky130_fd_sc_hd__a31oi_1
X_1039_ _0140_ result[15] VSS VDD VDD _0494_ sky130_fd_sc_hd__nand2_1
X_1040_ mm_phase base_r[15] VSS VDD VDD _0495_ sky130_fd_sc_hd__nand2_1
X_1041_ mm_b[15] net6 VSS VDD VDD _0496_ sky130_fd_sc_hd__nor2_1
X_1042_ net6 _0494_ _0495_ _0496_ VSS VDD VDD _0087_ sky130_fd_sc_hd__a31oi_1
X_1043_ result[9] _0140_ VSS VDD VDD _0497_ sky130_fd_sc_hd__nand2_1
X_1044_ mm_phase base_r[9] VSS VDD VDD _0498_ sky130_fd_sc_hd__nand2_1
X_1045_ mm_b[9] net6 VSS VDD VDD _0499_ sky130_fd_sc_hd__nor2_1
X_1046_ net6 _0497_ _0498_ _0499_ VSS VDD VDD _0088_ sky130_fd_sc_hd__a31oi_1
X_1047_ mod_in[15] mod_r[15] net5 VSS VDD VDD _0089_ sky130_fd_sc_hd__mux2_2
X_1048_ result[8] _0140_ VSS VDD VDD _0500_ sky130_fd_sc_hd__nand2_1
X_1049_ mm_phase base_r[8] VSS VDD VDD _0501_ sky130_fd_sc_hd__nand2_1
X_1050_ mm_b[8] net6 VSS VDD VDD _0502_ sky130_fd_sc_hd__nor2_1
X_1051_ net6 _0500_ _0501_ _0502_ VSS VDD VDD _0090_ sky130_fd_sc_hd__a31oi_1
X_1052_ result[7] _0140_ VSS VDD VDD _0503_ sky130_fd_sc_hd__nand2_1
X_1053_ mm_phase base_r[7] VSS VDD VDD _0504_ sky130_fd_sc_hd__nand2_1
X_1054_ mm_b[7] net6 VSS VDD VDD _0505_ sky130_fd_sc_hd__nor2_1
X_1055_ net6 _0503_ _0504_ _0505_ VSS VDD VDD _0091_ sky130_fd_sc_hd__a31oi_1
X_1056_ result[6] _0140_ VSS VDD VDD _0506_ sky130_fd_sc_hd__nand2_1
X_1057_ mm_phase base_r[6] VSS VDD VDD _0507_ sky130_fd_sc_hd__nand2_1
X_1058_ mm_b[6] net6 VSS VDD VDD _0508_ sky130_fd_sc_hd__nor2_1
X_1059_ net6 _0506_ _0507_ _0508_ VSS VDD VDD _0092_ sky130_fd_sc_hd__a31oi_1
X_1060_ result[5] _0140_ VSS VDD VDD _0509_ sky130_fd_sc_hd__nand2_1
X_1061_ mm_phase base_r[5] VSS VDD VDD _0510_ sky130_fd_sc_hd__nand2_1
X_1062_ mm_b[5] net6 VSS VDD VDD _0511_ sky130_fd_sc_hd__nor2_1
X_1063_ net6 _0509_ _0510_ _0511_ VSS VDD VDD _0093_ sky130_fd_sc_hd__a31oi_1
X_1064_ result[4] _0140_ VSS VDD VDD _0512_ sky130_fd_sc_hd__nand2_1
X_1065_ mm_phase base_r[4] VSS VDD VDD _0513_ sky130_fd_sc_hd__nand2_1
X_1066_ mm_b[4] net6 VSS VDD VDD _0514_ sky130_fd_sc_hd__nor2_1
X_1067_ net6 _0512_ _0513_ _0514_ VSS VDD VDD _0094_ sky130_fd_sc_hd__a31oi_1
X_1068_ result[3] _0140_ VSS VDD VDD _0515_ sky130_fd_sc_hd__nand2_1
X_1069_ mm_phase base_r[3] VSS VDD VDD _0516_ sky130_fd_sc_hd__nand2_1
X_1070_ mm_b[3] net6 VSS VDD VDD _0517_ sky130_fd_sc_hd__nor2_1
X_1071_ net6 _0515_ _0516_ _0517_ VSS VDD VDD _0095_ sky130_fd_sc_hd__a31oi_1
X_1072_ result[2] _0140_ VSS VDD VDD _0518_ sky130_fd_sc_hd__nand2_1
X_1073_ mm_phase base_r[2] VSS VDD VDD _0519_ sky130_fd_sc_hd__nand2_1
X_1074_ mm_b[2] net6 VSS VDD VDD _0520_ sky130_fd_sc_hd__nor2_1
X_1075_ net6 _0518_ _0519_ _0520_ VSS VDD VDD _0096_ sky130_fd_sc_hd__a31oi_1
X_1076_ result[1] _0140_ VSS VDD VDD _0521_ sky130_fd_sc_hd__nand2_1
X_1077_ mm_phase base_r[1] VSS VDD VDD _0522_ sky130_fd_sc_hd__nand2_1
X_1078_ mm_b[1] net6 VSS VDD VDD _0523_ sky130_fd_sc_hd__nor2_1
X_1079_ net6 _0521_ _0522_ _0523_ VSS VDD VDD _0097_ sky130_fd_sc_hd__a31oi_1
X_1080_ mm_b[0] net6 VSS VDD VDD _0524_ sky130_fd_sc_hd__nor2_1
X_1081_ _0159_ mm_phase net6 VSS VDD VDD _0525_ sky130_fd_sc_hd__o21ai_0
X_1082_ mm_phase base_r[0] _0525_ VSS VDD VDD _0526_ sky130_fd_sc_hd__a21oi_1
X_1083_ _0524_ _0526_ VSS VDD VDD _0098_ sky130_fd_sc_hd__nor2_1
X_1085_ exp_in[10] exp_r[9] state[1] VSS VDD VDD _0528_ sky130_fd_sc_hd__mux2i_1
X_1086_ exp_r[10] net3 VSS VDD VDD _0529_ sky130_fd_sc_hd__nand2_1
X_1087_ net3 _0528_ _0529_ VSS VDD VDD _0099_ sky130_fd_sc_hd__o21ai_0
X_1088_ base_in[15] base_r[15] net5 VSS VDD VDD _0100_ sky130_fd_sc_hd__mux2_2
X_1089_ exp_in[9] exp_r[8] state[1] VSS VDD VDD _0530_ sky130_fd_sc_hd__mux2i_1
X_1090_ exp_r[9] net3 VSS VDD VDD _0531_ sky130_fd_sc_hd__nand2_1
X_1091_ net3 _0530_ _0531_ VSS VDD VDD _0101_ sky130_fd_sc_hd__o21ai_0
X_1092_ exp_in[8] exp_r[7] state[1] VSS VDD VDD _0532_ sky130_fd_sc_hd__mux2i_1
X_1093_ exp_r[8] net3 VSS VDD VDD _0533_ sky130_fd_sc_hd__nand2_1
X_1094_ net3 _0532_ _0533_ VSS VDD VDD _0102_ sky130_fd_sc_hd__o21ai_0
X_1095_ exp_in[7] exp_r[6] state[1] VSS VDD VDD _0534_ sky130_fd_sc_hd__mux2i_1
X_1096_ exp_r[7] net3 VSS VDD VDD _0535_ sky130_fd_sc_hd__nand2_1
X_1097_ net3 _0534_ _0535_ VSS VDD VDD _0103_ sky130_fd_sc_hd__o21ai_0
X_1098_ exp_in[6] exp_r[5] state[1] VSS VDD VDD _0536_ sky130_fd_sc_hd__mux2i_1
X_1099_ exp_r[6] net3 VSS VDD VDD _0537_ sky130_fd_sc_hd__nand2_1
X_1100_ net3 _0536_ _0537_ VSS VDD VDD _0104_ sky130_fd_sc_hd__o21ai_0
X_1101_ _0458_ net3 VSS VDD VDD _0538_ sky130_fd_sc_hd__nand2_1
X_1102_ exp_r[15] _0132_ _0538_ VSS VDD VDD _0539_ sky130_fd_sc_hd__nand3_1
X_1103_ _0000_ net3 VSS VDD VDD _0540_ sky130_fd_sc_hd__or2_2
X_1104_ state[5] _0540_ VSS VDD VDD _0541_ sky130_fd_sc_hd__nor2_1
X_1105_ _0140_ _0539_ _0541_ VSS VDD VDD _0105_ sky130_fd_sc_hd__a21oi_1
X_1106_ exp_in[5] exp_r[4] state[1] VSS VDD VDD _0542_ sky130_fd_sc_hd__mux2i_1
X_1107_ exp_r[5] net3 VSS VDD VDD _0543_ sky130_fd_sc_hd__nand2_1
X_1108_ net3 _0542_ _0543_ VSS VDD VDD _0106_ sky130_fd_sc_hd__o21ai_0
X_1109_ exp_in[4] exp_r[3] state[1] VSS VDD VDD _0544_ sky130_fd_sc_hd__mux2i_1
X_1110_ exp_r[4] net3 VSS VDD VDD _0545_ sky130_fd_sc_hd__nand2_1
X_1111_ net3 _0544_ _0545_ VSS VDD VDD _0107_ sky130_fd_sc_hd__o21ai_0
X_1112_ result[15] _0453_ _0455_ mm_p[15] VSS VDD VDD _0108_ sky130_fd_sc_hd__a22o_1
X_1113_ exp_in[3] exp_r[2] state[1] VSS VDD VDD _0546_ sky130_fd_sc_hd__mux2i_1
X_1114_ exp_r[3] net3 VSS VDD VDD _0547_ sky130_fd_sc_hd__nand2_1
X_1115_ net3 _0546_ _0547_ VSS VDD VDD _0109_ sky130_fd_sc_hd__o21ai_0
X_1116_ _0291_ _0337_ _0338_ _0339_ VSS VDD VDD _0548_ sky130_fd_sc_hd__a31oi_1
X_1117_ _0337_ _0338_ _0548_ VSS VDD VDD _0549_ sky130_fd_sc_hd__o21ai_0
X_1118_ _0345_ _0549_ VSS VDD VDD _0550_ sky130_fd_sc_hd__nand2_1
X_1119_ _0219_ _0278_ _0284_ VSS VDD VDD _0551_ sky130_fd_sc_hd__nand3_1
X_1120_ _0285_ _0551_ VSS VDD VDD _0552_ sky130_fd_sc_hd__nand2b_1
X_1121_ _0292_ _0552_ VSS VDD VDD _0553_ sky130_fd_sc_hd__nand2_1
X_1122_ state[2] _0550_ _0553_ mm_p[15] net4 VSS VDD VDD _0110_ sky130_fd_sc_hd__a32o_1
X_1123_ exp_in[2] exp_r[1] state[1] VSS VDD VDD _0554_ sky130_fd_sc_hd__mux2i_1
X_1124_ exp_r[2] net3 VSS VDD VDD _0555_ sky130_fd_sc_hd__nand2_1
X_1125_ net3 _0554_ _0555_ VSS VDD VDD _0111_ sky130_fd_sc_hd__o21ai_0
X_1126_ exp_in[1] exp_r[0] state[1] VSS VDD VDD _0556_ sky130_fd_sc_hd__mux2i_1
X_1127_ exp_r[1] net3 VSS VDD VDD _0557_ sky130_fd_sc_hd__nand2_1
X_1128_ net3 _0556_ _0557_ VSS VDD VDD _0112_ sky130_fd_sc_hd__o21ai_0
X_1129_ state[1] net5 VSS VDD VDD _0558_ sky130_fd_sc_hd__nor2_1
X_1130_ exp_r[0] net3 _0558_ exp_in[0] VSS VDD VDD _0113_ sky130_fd_sc_hd__a22o_1
X_1131_ outer[0] outer[1] outer[2] _0460_ VSS VDD VDD _0559_ sky130_fd_sc_hd__nor4_1
X_1132_ outer[3] _0559_ VSS VDD VDD _0560_ sky130_fd_sc_hd__xnor2_1
X_1133_ _0558_ _0560_ VSS VDD VDD _0114_ sky130_fd_sc_hd__nor2_1
X_1134_ outer[0] outer[1] net3 outer[2] VSS VDD VDD _0561_ sky130_fd_sc_hd__o31a_1
X_1135_ _0559_ _0561_ VSS VDD VDD _0562_ sky130_fd_sc_hd__nor2_1
X_1136_ _0558_ _0562_ VSS VDD VDD _0115_ sky130_fd_sc_hd__nor2_1
X_1137_ j[4] _0164_ VSS VDD VDD _0563_ sky130_fd_sc_hd__xor2_1
X_1138_ _0160_ _0563_ VSS VDD VDD _0116_ sky130_fd_sc_hd__nand2_1
X_1139_ state[2] mm_a[14] net4 mm_a[15] _0149_ result[15] VSS VDD VDD _0564_ sky130_fd_sc_hd__a222oi_1
X_1140_ _0564_ VSS VDD VDD _0117_ sky130_fd_sc_hd__inv_1
X_1141_ outer[0] net3 VSS VDD VDD _0565_ sky130_fd_sc_hd__nor2_1
X_1142_ outer[1] _0565_ VSS VDD VDD _0566_ sky130_fd_sc_hd__xnor2_1
X_1143_ _0558_ _0566_ VSS VDD VDD _0118_ sky130_fd_sc_hd__nor2_1
X_1144_ outer[0] _0540_ VSS VDD VDD _0567_ sky130_fd_sc_hd__nand2_1
X_1145_ state[1] _0565_ VSS VDD VDD _0568_ sky130_fd_sc_hd__nand2_1
X_1146_ _0567_ _0568_ VSS VDD VDD _0119_ sky130_fd_sc_hd__nand2_1
X_1147_ outer[3] VSS VDD VDD _0569_ sky130_fd_sc_hd__inv_1
X_1148_ outer[4] VSS VDD VDD _0570_ sky130_fd_sc_hd__inv_1
X_1149_ _0569_ _0570_ _0559_ VSS VDD VDD _0571_ sky130_fd_sc_hd__nand3_1
X_1150_ _0569_ _0559_ _0570_ VSS VDD VDD _0572_ sky130_fd_sc_hd__a21oi_1
X_1151_ _0558_ _0572_ VSS VDD VDD _0573_ sky130_fd_sc_hd__nor2_1
X_1152_ _0571_ _0573_ VSS VDD VDD _0120_ sky130_fd_sc_hd__nand2_1
X_1153_ exp_in[15] exp_r[14] state[1] VSS VDD VDD _0574_ sky130_fd_sc_hd__mux2i_1
X_1154_ exp_r[15] net3 VSS VDD VDD _0575_ sky130_fd_sc_hd__nand2_1
X_1155_ net3 _0574_ _0575_ VSS VDD VDD _0121_ sky130_fd_sc_hd__o21ai_0
X_1156_ mm_a[13] state[2] mm_a[14] net4 _0149_ result[14] VSS VDD VDD _0576_ sky130_fd_sc_hd__a222oi_1
X_1157_ _0576_ VSS VDD VDD _0122_ sky130_fd_sc_hd__inv_1
X_1158_ state[2] mm_a[12] _0149_ result[13] net4 mm_a[13] VSS VDD VDD _0577_ sky130_fd_sc_hd__a222oi_1
X_1159_ _0577_ VSS VDD VDD _0123_ sky130_fd_sc_hd__inv_1
X_1160_ state[2] mm_a[11] net4 mm_a[12] _0149_ result[12] VSS VDD VDD _0578_ sky130_fd_sc_hd__a222oi_1
X_1161_ _0578_ VSS VDD VDD _0124_ sky130_fd_sc_hd__inv_1
X_1162_ state[2] mm_a[10] net4 mm_a[11] _0149_ result[11] VSS VDD VDD _0579_ sky130_fd_sc_hd__a222oi_1
X_1163_ _0579_ VSS VDD VDD _0125_ sky130_fd_sc_hd__inv_1
X_1164_ state[2] mm_a[9] net4 mm_a[10] _0149_ result[10] VSS VDD VDD _0580_ sky130_fd_sc_hd__a222oi_1
X_1165_ _0580_ VSS VDD VDD _0126_ sky130_fd_sc_hd__inv_1
X_1166_ state[2] mm_a[8] net4 mm_a[9] _0149_ result[9] VSS VDD VDD _0581_ sky130_fd_sc_hd__a222oi_1
X_1167_ _0581_ VSS VDD VDD _0127_ sky130_fd_sc_hd__inv_1
X_1168_ state[2] mm_a[7] net4 mm_a[8] _0149_ result[8] VSS VDD VDD _0582_ sky130_fd_sc_hd__a222oi_1
X_1169_ _0582_ VSS VDD VDD _0128_ sky130_fd_sc_hd__inv_1
X_1170_ clknet_4_3_0_clk _0098_ mm_b[0] rst_n VSS VDD VDD sky130_fd_sc_hd__dfrtp_1
X_1171_ clknet_4_12_0_clk _0097_ mm_b[1] rst_n VSS VDD VDD sky130_fd_sc_hd__dfrtp_1
X_1172_ clknet_4_12_0_clk _0096_ mm_b[2] rst_n VSS VDD VDD sky130_fd_sc_hd__dfrtp_1
X_1173_ clknet_4_11_0_clk _0095_ mm_b[3] rst_n VSS VDD VDD sky130_fd_sc_hd__dfrtp_1
X_1174_ clknet_4_14_0_clk _0094_ mm_b[4] rst_n VSS VDD VDD sky130_fd_sc_hd__dfrtp_1
X_1175_ clknet_4_14_0_clk _0093_ mm_b[5] rst_n VSS VDD VDD sky130_fd_sc_hd__dfrtp_1
X_1176_ clknet_4_15_0_clk _0092_ mm_b[6] rst_n VSS VDD VDD sky130_fd_sc_hd__dfrtp_1
X_1177_ clknet_4_11_0_clk _0091_ mm_b[7] rst_n VSS VDD VDD sky130_fd_sc_hd__dfrtp_1
X_1178_ clknet_4_9_0_clk _0090_ mm_b[8] rst_n VSS VDD VDD sky130_fd_sc_hd__dfrtp_1
X_1179_ clknet_4_12_0_clk _0088_ mm_b[9] rst_n VSS VDD VDD sky130_fd_sc_hd__dfrtp_1
X_1180_ clknet_4_12_0_clk _0086_ mm_b[10] rst_n VSS VDD VDD sky130_fd_sc_hd__dfrtp_1
X_1181_ clknet_4_6_0_clk _0085_ mm_b[11] rst_n VSS VDD VDD sky130_fd_sc_hd__dfrtp_1
X_1182_ clknet_4_6_0_clk _0084_ mm_b[12] rst_n VSS VDD VDD sky130_fd_sc_hd__dfrtp_1
X_1183_ clknet_4_3_0_clk _0083_ mm_b[13] rst_n VSS VDD VDD sky130_fd_sc_hd__dfrtp_1
X_1184_ clknet_4_1_0_clk _0082_ mm_b[14] rst_n VSS VDD VDD sky130_fd_sc_hd__dfrtp_1
X_1185_ clknet_4_1_0_clk _0087_ mm_b[15] rst_n VSS VDD VDD sky130_fd_sc_hd__dfrtp_1
X_1186_ clknet_4_9_0_clk _0081_ mod_r[0] rst_n VSS VDD VDD sky130_fd_sc_hd__dfrtp_1
X_1187_ clknet_4_15_0_clk _0080_ mod_r[1] rst_n VSS VDD VDD sky130_fd_sc_hd__dfrtp_1
X_1188_ clknet_4_3_0_clk _0079_ mod_r[2] rst_n VSS VDD VDD sky130_fd_sc_hd__dfrtp_1
X_1189_ clknet_4_15_0_clk _0078_ mod_r[3] rst_n VSS VDD VDD sky130_fd_sc_hd__dfrtp_1
X_1190_ clknet_4_15_0_clk _0077_ mod_r[4] rst_n VSS VDD VDD sky130_fd_sc_hd__dfrtp_1
X_1191_ clknet_4_15_0_clk _0076_ mod_r[5] rst_n VSS VDD VDD sky130_fd_sc_hd__dfrtp_1
X_1192_ clknet_4_11_0_clk _0075_ mod_r[6] rst_n VSS VDD VDD sky130_fd_sc_hd__dfrtp_1
X_1193_ clknet_4_15_0_clk _0074_ mod_r[7] rst_n VSS VDD VDD sky130_fd_sc_hd__dfrtp_1
X_1194_ clknet_4_8_0_clk _0073_ mod_r[8] rst_n VSS VDD VDD sky130_fd_sc_hd__dfrtp_1
X_1195_ clknet_4_9_0_clk _0072_ mod_r[9] rst_n VSS VDD VDD sky130_fd_sc_hd__dfrtp_1
X_1196_ clknet_4_2_0_clk _0071_ mod_r[10] rst_n VSS VDD VDD sky130_fd_sc_hd__dfrtp_1
X_1197_ clknet_4_8_0_clk _0070_ mod_r[11] rst_n VSS VDD VDD sky130_fd_sc_hd__dfrtp_1
X_1198_ clknet_4_13_0_clk _0069_ mod_r[12] rst_n VSS VDD VDD sky130_fd_sc_hd__dfrtp_1
X_1199_ clknet_4_0_0_clk _0068_ mod_r[13] rst_n VSS VDD VDD sky130_fd_sc_hd__dfrtp_1
X_1200_ clknet_4_0_0_clk _0067_ mod_r[14] rst_n VSS VDD VDD sky130_fd_sc_hd__dfrtp_1
X_1201_ clknet_4_1_0_clk _0089_ mod_r[15] rst_n VSS VDD VDD sky130_fd_sc_hd__dfrtp_1
X_1202_ clknet_4_6_0_clk _0066_ base_r[0] rst_n VSS VDD VDD sky130_fd_sc_hd__dfrtp_1
X_1203_ clknet_4_12_0_clk _0065_ base_r[1] rst_n VSS VDD VDD sky130_fd_sc_hd__dfrtp_1
X_1204_ clknet_4_13_0_clk _0064_ base_r[2] rst_n VSS VDD VDD sky130_fd_sc_hd__dfrtp_1
X_1205_ clknet_4_7_0_clk _0063_ base_r[3] rst_n VSS VDD VDD sky130_fd_sc_hd__dfrtp_1
X_1206_ clknet_4_15_0_clk _0062_ base_r[4] rst_n VSS VDD VDD sky130_fd_sc_hd__dfrtp_1
X_1207_ clknet_4_15_0_clk _0061_ base_r[5] rst_n VSS VDD VDD sky130_fd_sc_hd__dfrtp_1
X_1208_ clknet_4_7_0_clk _0060_ base_r[6] rst_n VSS VDD VDD sky130_fd_sc_hd__dfrtp_1
X_1209_ clknet_4_13_0_clk _0059_ base_r[7] rst_n VSS VDD VDD sky130_fd_sc_hd__dfrtp_1
X_1210_ clknet_4_6_0_clk _0058_ base_r[8] rst_n VSS VDD VDD sky130_fd_sc_hd__dfrtp_1
X_1211_ clknet_4_6_0_clk _0057_ base_r[9] rst_n VSS VDD VDD sky130_fd_sc_hd__dfrtp_1
X_1212_ clknet_4_7_0_clk _0056_ base_r[10] rst_n VSS VDD VDD sky130_fd_sc_hd__dfrtp_1
X_1213_ clknet_4_6_0_clk _0055_ base_r[11] rst_n VSS VDD VDD sky130_fd_sc_hd__dfrtp_1
X_1214_ clknet_4_7_0_clk _0054_ base_r[12] rst_n VSS VDD VDD sky130_fd_sc_hd__dfrtp_1
X_1215_ clknet_4_6_0_clk _0053_ base_r[13] rst_n VSS VDD VDD sky130_fd_sc_hd__dfrtp_1
X_1216_ clknet_4_1_0_clk _0052_ base_r[14] rst_n VSS VDD VDD sky130_fd_sc_hd__dfrtp_1
X_1217_ clknet_4_4_0_clk _0100_ base_r[15] rst_n VSS VDD VDD sky130_fd_sc_hd__dfrtp_1
X_1218_ clknet_4_4_0_clk _0105_ mm_phase rst_n VSS VDD VDD sky130_fd_sc_hd__dfrtp_1
X_1219_ clknet_4_13_0_clk _0047_ result[0] rst_n VSS VDD VDD sky130_fd_sc_hd__dfrtp_1
X_1220_ clknet_4_14_0_clk _0046_ result[1] rst_n VSS VDD VDD sky130_fd_sc_hd__dfrtp_1
X_1221_ clknet_4_11_0_clk _0045_ result[2] rst_n VSS VDD VDD sky130_fd_sc_hd__dfrtp_1
X_1222_ clknet_4_14_0_clk _0044_ result[3] rst_n VSS VDD VDD sky130_fd_sc_hd__dfrtp_1
X_1223_ clknet_4_11_0_clk _0043_ result[4] rst_n VSS VDD VDD sky130_fd_sc_hd__dfrtp_1
X_1224_ clknet_4_11_0_clk _0042_ result[5] rst_n VSS VDD VDD sky130_fd_sc_hd__dfrtp_1
X_1225_ clknet_4_14_0_clk _0041_ result[6] rst_n VSS VDD VDD sky130_fd_sc_hd__dfrtp_1
X_1226_ clknet_4_11_0_clk _0040_ result[7] rst_n VSS VDD VDD sky130_fd_sc_hd__dfrtp_1
X_1227_ clknet_4_14_0_clk _0039_ result[8] rst_n VSS VDD VDD sky130_fd_sc_hd__dfrtp_1
X_1228_ clknet_4_14_0_clk _0038_ result[9] rst_n VSS VDD VDD sky130_fd_sc_hd__dfrtp_1
X_1229_ clknet_4_9_0_clk _0037_ result[10] rst_n VSS VDD VDD sky130_fd_sc_hd__dfrtp_1
X_1230_ clknet_4_9_0_clk _0036_ result[11] rst_n VSS VDD VDD sky130_fd_sc_hd__dfrtp_1
X_1231_ clknet_4_3_0_clk _0035_ result[12] rst_n VSS VDD VDD sky130_fd_sc_hd__dfrtp_1
X_1232_ clknet_4_3_0_clk _0034_ result[13] rst_n VSS VDD VDD sky130_fd_sc_hd__dfrtp_1
X_1233_ clknet_4_2_0_clk _0033_ result[14] rst_n VSS VDD VDD sky130_fd_sc_hd__dfrtp_1
X_1234_ clknet_4_0_0_clk _0108_ result[15] rst_n VSS VDD VDD sky130_fd_sc_hd__dfrtp_1
X_1235_ clknet_4_8_0_clk _0032_ mm_p[0] rst_n VSS VDD VDD sky130_fd_sc_hd__dfrtp_1
X_1236_ clknet_4_10_0_clk _0031_ mm_p[1] rst_n VSS VDD VDD sky130_fd_sc_hd__dfrtp_1
X_1237_ clknet_4_11_0_clk _0030_ mm_p[2] rst_n VSS VDD VDD sky130_fd_sc_hd__dfrtp_1
X_1238_ clknet_4_10_0_clk _0029_ mm_p[3] rst_n VSS VDD VDD sky130_fd_sc_hd__dfrtp_1
X_1239_ clknet_4_10_0_clk _0028_ mm_p[4] rst_n VSS VDD VDD sky130_fd_sc_hd__dfrtp_1
X_1240_ clknet_4_10_0_clk _0027_ mm_p[5] rst_n VSS VDD VDD sky130_fd_sc_hd__dfrtp_1
X_1241_ clknet_4_10_0_clk _0026_ mm_p[6] rst_n VSS VDD VDD sky130_fd_sc_hd__dfrtp_1
X_1242_ clknet_4_10_0_clk _0025_ mm_p[7] rst_n VSS VDD VDD sky130_fd_sc_hd__dfrtp_1
X_1243_ clknet_4_10_0_clk _0024_ mm_p[8] rst_n VSS VDD VDD sky130_fd_sc_hd__dfrtp_1
X_1244_ clknet_4_8_0_clk _0023_ mm_p[9] rst_n VSS VDD VDD sky130_fd_sc_hd__dfrtp_1
X_1245_ clknet_4_8_0_clk _0022_ mm_p[10] rst_n VSS VDD VDD sky130_fd_sc_hd__dfrtp_1
X_1246_ clknet_4_8_0_clk _0021_ mm_p[11] rst_n VSS VDD VDD sky130_fd_sc_hd__dfrtp_1
X_1247_ clknet_4_2_0_clk _0020_ mm_p[12] rst_n VSS VDD VDD sky130_fd_sc_hd__dfrtp_1
X_1248_ clknet_4_2_0_clk _0019_ mm_p[13] rst_n VSS VDD VDD sky130_fd_sc_hd__dfrtp_1
X_1249_ clknet_4_2_0_clk _0018_ mm_p[14] rst_n VSS VDD VDD sky130_fd_sc_hd__dfrtp_1
X_1250_ clknet_4_0_0_clk _0110_ mm_p[15] rst_n VSS VDD VDD sky130_fd_sc_hd__dfrtp_1
X_1251_ clknet_4_0_0_clk _0017_ j[0] rst_n VSS VDD VDD sky130_fd_sc_hd__dfrtp_1
X_1252_ clknet_4_1_0_clk _0016_ j[1] rst_n VSS VDD VDD sky130_fd_sc_hd__dfrtp_1
X_1253_ clknet_4_1_0_clk _0015_ j[2] rst_n VSS VDD VDD sky130_fd_sc_hd__dfrtp_1
X_1254_ clknet_4_1_0_clk _0014_ j[3] rst_n VSS VDD VDD sky130_fd_sc_hd__dfrtp_1
X_1255_ clknet_4_4_0_clk _0116_ j[4] rst_n VSS VDD VDD sky130_fd_sc_hd__dfrtp_1
X_1256_ clknet_4_12_0_clk _0013_ mm_a[0] rst_n VSS VDD VDD sky130_fd_sc_hd__dfrtp_1
X_1257_ clknet_4_14_0_clk _0012_ mm_a[1] rst_n VSS VDD VDD sky130_fd_sc_hd__dfrtp_1
X_1258_ clknet_4_14_0_clk _0011_ mm_a[2] rst_n VSS VDD VDD sky130_fd_sc_hd__dfrtp_1
X_1259_ clknet_4_14_0_clk _0010_ mm_a[3] rst_n VSS VDD VDD sky130_fd_sc_hd__dfrtp_1
X_1260_ clknet_4_14_0_clk _0009_ mm_a[4] rst_n VSS VDD VDD sky130_fd_sc_hd__dfrtp_1
X_1261_ clknet_4_15_0_clk _0008_ mm_a[5] rst_n VSS VDD VDD sky130_fd_sc_hd__dfrtp_1
X_1262_ clknet_4_15_0_clk _0007_ mm_a[6] rst_n VSS VDD VDD sky130_fd_sc_hd__dfrtp_1
X_1263_ clknet_4_15_0_clk _0006_ mm_a[7] rst_n VSS VDD VDD sky130_fd_sc_hd__dfrtp_1
X_1264_ clknet_4_15_0_clk _0128_ mm_a[8] rst_n VSS VDD VDD sky130_fd_sc_hd__dfrtp_1
X_1265_ clknet_4_15_0_clk _0127_ mm_a[9] rst_n VSS VDD VDD sky130_fd_sc_hd__dfrtp_1
X_1266_ clknet_4_15_0_clk _0126_ mm_a[10] rst_n VSS VDD VDD sky130_fd_sc_hd__dfrtp_1
X_1267_ clknet_4_13_0_clk _0125_ mm_a[11] rst_n VSS VDD VDD sky130_fd_sc_hd__dfrtp_1
X_1268_ clknet_4_12_0_clk _0124_ mm_a[12] rst_n VSS VDD VDD sky130_fd_sc_hd__dfrtp_1
X_1269_ clknet_4_9_0_clk _0123_ mm_a[13] rst_n VSS VDD VDD sky130_fd_sc_hd__dfrtp_1
X_1270_ clknet_4_3_0_clk _0122_ mm_a[14] rst_n VSS VDD VDD sky130_fd_sc_hd__dfrtp_1
X_1271_ clknet_4_9_0_clk _0117_ mm_a[15] rst_n VSS VDD VDD sky130_fd_sc_hd__dfrtp_1
X_1272_ clknet_4_4_0_clk _0119_ outer[0] rst_n VSS VDD VDD sky130_fd_sc_hd__dfrtp_1
X_1273_ clknet_4_5_0_clk _0118_ outer[1] rst_n VSS VDD VDD sky130_fd_sc_hd__dfrtp_1
X_1274_ clknet_4_5_0_clk _0115_ outer[2] rst_n VSS VDD VDD sky130_fd_sc_hd__dfrtp_1
X_1275_ clknet_4_5_0_clk _0114_ outer[3] rst_n VSS VDD VDD sky130_fd_sc_hd__dfrtp_1
X_1276_ clknet_4_5_0_clk _0120_ outer[4] rst_n VSS VDD VDD sky130_fd_sc_hd__dfrtp_1
X_1277_ clknet_4_13_0_clk _0113_ exp_r[0] rst_n VSS VDD VDD sky130_fd_sc_hd__dfrtp_1
X_1278_ clknet_4_13_0_clk _0112_ exp_r[1] rst_n VSS VDD VDD sky130_fd_sc_hd__dfrtp_1
X_1279_ clknet_4_13_0_clk _0111_ exp_r[2] rst_n VSS VDD VDD sky130_fd_sc_hd__dfrtp_1
X_1280_ clknet_4_7_0_clk _0109_ exp_r[3] rst_n VSS VDD VDD sky130_fd_sc_hd__dfrtp_1
X_1281_ clknet_4_7_0_clk _0107_ exp_r[4] rst_n VSS VDD VDD sky130_fd_sc_hd__dfrtp_1
X_1282_ clknet_4_7_0_clk _0106_ exp_r[5] rst_n VSS VDD VDD sky130_fd_sc_hd__dfrtp_1
X_1283_ clknet_4_5_0_clk _0104_ exp_r[6] rst_n VSS VDD VDD sky130_fd_sc_hd__dfrtp_1
X_1284_ clknet_4_5_0_clk _0103_ exp_r[7] rst_n VSS VDD VDD sky130_fd_sc_hd__dfrtp_1
X_1285_ clknet_4_5_0_clk _0102_ exp_r[8] rst_n VSS VDD VDD sky130_fd_sc_hd__dfrtp_1
X_1286_ clknet_4_5_0_clk _0101_ exp_r[9] rst_n VSS VDD VDD sky130_fd_sc_hd__dfrtp_1
X_1287_ clknet_4_7_0_clk _0099_ exp_r[10] rst_n VSS VDD VDD sky130_fd_sc_hd__dfrtp_1
X_1288_ clknet_4_13_0_clk _0051_ exp_r[11] rst_n VSS VDD VDD sky130_fd_sc_hd__dfrtp_1
X_1289_ clknet_4_13_0_clk _0050_ exp_r[12] rst_n VSS VDD VDD sky130_fd_sc_hd__dfrtp_1
X_1290_ clknet_4_7_0_clk _0049_ exp_r[13] rst_n VSS VDD VDD sky130_fd_sc_hd__dfrtp_1
X_1291_ clknet_4_5_0_clk _0048_ exp_r[14] rst_n VSS VDD VDD sky130_fd_sc_hd__dfrtp_1
X_1292_ clknet_4_5_0_clk _0121_ exp_r[15] rst_n VSS VDD VDD sky130_fd_sc_hd__dfrtp_1
X_1293_ clknet_4_4_0_clk _0002_ state[0] rst_n VSS VDD VDD sky130_fd_sc_hd__dfstp_2
X_1294_ clknet_4_4_0_clk _0003_ state[1] rst_n VSS VDD VDD sky130_fd_sc_hd__dfrtp_1
X_1295_ clknet_4_0_0_clk _0004_ state[2] rst_n VSS VDD VDD sky130_fd_sc_hd__dfrtp_1
X_1296_ clknet_4_4_0_clk _0005_ state[3] rst_n VSS VDD VDD sky130_fd_sc_hd__dfrtp_1
X_1297_ clknet_4_5_0_clk _0000_ state[4] rst_n VSS VDD VDD sky130_fd_sc_hd__dfrtp_1
X_1298_ clknet_4_4_0_clk _0001_ state[5] rst_n VSS VDD VDD sky130_fd_sc_hd__dfrtp_1
X_1299_ clknet_4_5_0_clk state[4] done rst_n VSS VDD VDD sky130_fd_sc_hd__dfrtp_1
X_1300_ _unconn__1300__HI_ _0583_ VSS VDD VDD sky130_fd_sc_hd__conb_1
X_1301_ _unconn__1301__HI_ _0584_ VSS VDD VDD sky130_fd_sc_hd__conb_1
X_1302_ _unconn__1302__HI_ _0585_ VSS VDD VDD sky130_fd_sc_hd__conb_1
X_1303_ _unconn__1303__HI_ _0586_ VSS VDD VDD sky130_fd_sc_hd__conb_1
Xclkbuf_0_clk clk VSS VDD VDD clknet_0_clk sky130_fd_sc_hd__buf_4
Xclkbuf_4_0_0_clk clknet_0_clk VSS VDD VDD clknet_4_0_0_clk sky130_fd_sc_hd__buf_4
Xclkbuf_4_10_0_clk clknet_0_clk VSS VDD VDD clknet_4_10_0_clk sky130_fd_sc_hd__buf_4
Xclkbuf_4_11_0_clk clknet_0_clk VSS VDD VDD clknet_4_11_0_clk sky130_fd_sc_hd__buf_4
Xclkbuf_4_12_0_clk clknet_0_clk VSS VDD VDD clknet_4_12_0_clk sky130_fd_sc_hd__buf_4
Xclkbuf_4_13_0_clk clknet_0_clk VSS VDD VDD clknet_4_13_0_clk sky130_fd_sc_hd__buf_4
Xclkbuf_4_14_0_clk clknet_0_clk VSS VDD VDD clknet_4_14_0_clk sky130_fd_sc_hd__buf_4
Xclkbuf_4_15_0_clk clknet_0_clk VSS VDD VDD clknet_4_15_0_clk sky130_fd_sc_hd__buf_4
Xclkbuf_4_1_0_clk clknet_0_clk VSS VDD VDD clknet_4_1_0_clk sky130_fd_sc_hd__buf_4
Xclkbuf_4_2_0_clk clknet_0_clk VSS VDD VDD clknet_4_2_0_clk sky130_fd_sc_hd__buf_4
Xclkbuf_4_3_0_clk clknet_0_clk VSS VDD VDD clknet_4_3_0_clk sky130_fd_sc_hd__buf_4
Xclkbuf_4_4_0_clk clknet_0_clk VSS VDD VDD clknet_4_4_0_clk sky130_fd_sc_hd__buf_4
Xclkbuf_4_5_0_clk clknet_0_clk VSS VDD VDD clknet_4_5_0_clk sky130_fd_sc_hd__buf_4
Xclkbuf_4_6_0_clk clknet_0_clk VSS VDD VDD clknet_4_6_0_clk sky130_fd_sc_hd__buf_4
Xclkbuf_4_7_0_clk clknet_0_clk VSS VDD VDD clknet_4_7_0_clk sky130_fd_sc_hd__buf_4
Xclkbuf_4_8_0_clk clknet_0_clk VSS VDD VDD clknet_4_8_0_clk sky130_fd_sc_hd__buf_4
Xclkbuf_4_9_0_clk clknet_0_clk VSS VDD VDD clknet_4_9_0_clk sky130_fd_sc_hd__buf_4
Xclkload0 clknet_4_0_0_clk VSS VDD VDD _unconn_clkload0_Y_ sky130_fd_sc_hd__inv_6
Xclkload1 clknet_4_1_0_clk VSS VDD VDD _unconn_clkload1_Y_ sky130_fd_sc_hd__inv_6
Xclkload10 clknet_4_10_0_clk VSS VDD VDD _unconn_clkload10_Y_ sky130_fd_sc_hd__inv_6
Xclkload11 clknet_4_11_0_clk VSS VDD VDD _unconn_clkload11_Y_ sky130_fd_sc_hd__clkinv_4
Xclkload12 clknet_4_12_0_clk VSS VDD VDD _unconn_clkload12_Y_ sky130_fd_sc_hd__inv_6
Xclkload13 clknet_4_13_0_clk VSS VDD VDD _unconn_clkload13_Y_ sky130_fd_sc_hd__bufinv_16
Xclkload14 clknet_4_14_0_clk VSS VDD VDD _unconn_clkload14_Y_ sky130_fd_sc_hd__clkinv_2
Xclkload2 clknet_4_2_0_clk VSS VDD VDD _unconn_clkload2_Y_ sky130_fd_sc_hd__inv_8
Xclkload3 clknet_4_3_0_clk VSS VDD VDD _unconn_clkload3_Y_ sky130_fd_sc_hd__inv_6
Xclkload4 clknet_4_4_0_clk VSS VDD VDD _unconn_clkload4_Y_ sky130_fd_sc_hd__clkinv_4
Xclkload5 clknet_4_5_0_clk VSS VDD VDD _unconn_clkload5_Y_ sky130_fd_sc_hd__clkinv_1
Xclkload6 clknet_4_6_0_clk VSS VDD VDD _unconn_clkload6_Y_ sky130_fd_sc_hd__inv_6
Xclkload7 clknet_4_7_0_clk VSS VDD VDD _unconn_clkload7_Y_ sky130_fd_sc_hd__clkinvlp_4
Xclkload8 clknet_4_8_0_clk VSS VDD VDD _unconn_clkload8_Y_ sky130_fd_sc_hd__inv_6
Xclkload9 clknet_4_9_0_clk VSS VDD VDD _unconn_clkload9_Y_ sky130_fd_sc_hd__inv_6
Xplace3 _0460_ VSS VDD VDD net3 sky130_fd_sc_hd__buf_4
Xplace4 _0147_ VSS VDD VDD net4 sky130_fd_sc_hd__buf_4
Xplace5 _0471_ VSS VDD VDD net5 sky130_fd_sc_hd__buf_4
Xplace6 state[3] VSS VDD VDD net6 sky130_fd_sc_hd__buf_4
.ENDS modexp

.SUBCKT sky130_fd_sc_hd__diode_2 DIODE VGND VPB VPWR
.ENDS sky130_fd_sc_hd__diode_2

.SUBCKT sky130_fd_sc_hd__nand2b_1 A_N B VGND VPB VPWR Y
.ENDS sky130_fd_sc_hd__nand2b_1

.SUBCKT sky130_fd_sc_hd__nor4_1 A B C D VGND VPB VPWR Y
.ENDS sky130_fd_sc_hd__nor4_1

.SUBCKT sky130_fd_sc_hd__nand2_1 A B VGND VPB VPWR Y
.ENDS sky130_fd_sc_hd__nand2_1

.SUBCKT sky130_fd_sc_hd__inv_1 A VGND VPB VPWR Y
.ENDS sky130_fd_sc_hd__inv_1

.SUBCKT sky130_fd_sc_hd__and2_1 A B VGND VPB VPWR X
.ENDS sky130_fd_sc_hd__and2_1

.SUBCKT sky130_fd_sc_hd__clkinv_1 A VGND VPB VPWR Y
.ENDS sky130_fd_sc_hd__clkinv_1

.SUBCKT sky130_fd_sc_hd__a21boi_0 A1 A2 B1_N VGND VPB VPWR Y
.ENDS sky130_fd_sc_hd__a21boi_0

.SUBCKT sky130_fd_sc_hd__a32oi_1 A1 A2 A3 B1 B2 VGND VPB VPWR Y
.ENDS sky130_fd_sc_hd__a32oi_1

.SUBCKT sky130_fd_sc_hd__o21ai_0 A1 A2 B1 VGND VPB VPWR Y
.ENDS sky130_fd_sc_hd__o21ai_0

.SUBCKT sky130_fd_sc_hd__nor2_1 A B VGND VPB VPWR Y
.ENDS sky130_fd_sc_hd__nor2_1

.SUBCKT sky130_fd_sc_hd__nor2b_1 A B_N VGND VPB VPWR Y
.ENDS sky130_fd_sc_hd__nor2b_1

.SUBCKT sky130_fd_sc_hd__a222oi_1 A1 A2 B1 B2 C1 C2 VGND VPB VPWR Y
.ENDS sky130_fd_sc_hd__a222oi_1

.SUBCKT sky130_fd_sc_hd__nor3_1 A B C VGND VPB VPWR Y
.ENDS sky130_fd_sc_hd__nor3_1

.SUBCKT sky130_fd_sc_hd__nand3b_1 A_N B C VGND VPB VPWR Y
.ENDS sky130_fd_sc_hd__nand3b_1

.SUBCKT sky130_fd_sc_hd__nand3_1 A B C VGND VPB VPWR Y
.ENDS sky130_fd_sc_hd__nand3_1

.SUBCKT sky130_fd_sc_hd__o311ai_0 A1 A2 A3 B1 C1 VGND VPB VPWR Y
.ENDS sky130_fd_sc_hd__o311ai_0

.SUBCKT sky130_fd_sc_hd__a32o_1 A1 A2 A3 B1 B2 VGND VPB VPWR X
.ENDS sky130_fd_sc_hd__a32o_1

.SUBCKT sky130_fd_sc_hd__a21oi_1 A1 A2 B1 VGND VPB VPWR Y
.ENDS sky130_fd_sc_hd__a21oi_1

.SUBCKT sky130_fd_sc_hd__a21o_1 A1 A2 B1 VGND VPB VPWR X
.ENDS sky130_fd_sc_hd__a21o_1

.SUBCKT sky130_fd_sc_hd__and3_1 A B C VGND VPB VPWR X
.ENDS sky130_fd_sc_hd__and3_1

.SUBCKT sky130_fd_sc_hd__o21ai_1 A1 A2 B1 VGND VPB VPWR Y
.ENDS sky130_fd_sc_hd__o21ai_1

.SUBCKT sky130_fd_sc_hd__a211o_1 A1 A2 B1 C1 VGND VPB VPWR X
.ENDS sky130_fd_sc_hd__a211o_1

.SUBCKT sky130_fd_sc_hd__a311o_1 A1 A2 A3 B1 C1 VGND VPB VPWR X
.ENDS sky130_fd_sc_hd__a311o_1

.SUBCKT sky130_fd_sc_hd__a31o_1 A1 A2 A3 B1 VGND VPB VPWR X
.ENDS sky130_fd_sc_hd__a31o_1

.SUBCKT sky130_fd_sc_hd__maj3_2 A B C VGND VPB VPWR X
.ENDS sky130_fd_sc_hd__maj3_2

.SUBCKT sky130_fd_sc_hd__a211oi_2 A1 A2 B1 C1 VGND VPB VPWR Y
.ENDS sky130_fd_sc_hd__a211oi_2

.SUBCKT sky130_fd_sc_hd__o31ai_1 A1 A2 A3 B1 VGND VPB VPWR Y
.ENDS sky130_fd_sc_hd__o31ai_1

.SUBCKT sky130_fd_sc_hd__xnor2_2 A B VGND VPB VPWR Y
.ENDS sky130_fd_sc_hd__xnor2_2

.SUBCKT sky130_fd_sc_hd__or2_2 A B VGND VPB VPWR X
.ENDS sky130_fd_sc_hd__or2_2

.SUBCKT sky130_fd_sc_hd__xor2_1 A B VGND VPB VPWR X
.ENDS sky130_fd_sc_hd__xor2_1

.SUBCKT sky130_fd_sc_hd__a21oi_2 A1 A2 B1 VGND VPB VPWR Y
.ENDS sky130_fd_sc_hd__a21oi_2

.SUBCKT sky130_fd_sc_hd__xor2_2 A B VGND VPB VPWR X
.ENDS sky130_fd_sc_hd__xor2_2

.SUBCKT sky130_fd_sc_hd__xnor2_1 A B VGND VPB VPWR Y
.ENDS sky130_fd_sc_hd__xnor2_1

.SUBCKT sky130_fd_sc_hd__a31oi_1 A1 A2 A3 B1 VGND VPB VPWR Y
.ENDS sky130_fd_sc_hd__a31oi_1

.SUBCKT sky130_fd_sc_hd__xnor3_1 A B C VGND VPB VPWR X
.ENDS sky130_fd_sc_hd__xnor3_1

.SUBCKT sky130_fd_sc_hd__maj3_1 A B C VGND VPB VPWR X
.ENDS sky130_fd_sc_hd__maj3_1

.SUBCKT sky130_fd_sc_hd__o211a_1 A1 A2 B1 C1 VGND VPB VPWR X
.ENDS sky130_fd_sc_hd__o211a_1

.SUBCKT sky130_fd_sc_hd__o211ai_1 A1 A2 B1 C1 VGND VPB VPWR Y
.ENDS sky130_fd_sc_hd__o211ai_1

.SUBCKT sky130_fd_sc_hd__o21a_1 A1 A2 B1 VGND VPB VPWR X
.ENDS sky130_fd_sc_hd__o21a_1

.SUBCKT sky130_fd_sc_hd__o21ai_2 A1 A2 B1 VGND VPB VPWR Y
.ENDS sky130_fd_sc_hd__o21ai_2

.SUBCKT sky130_fd_sc_hd__o31a_4 A1 A2 A3 B1 VGND VPB VPWR X
.ENDS sky130_fd_sc_hd__o31a_4

.SUBCKT sky130_fd_sc_hd__o311a_1 A1 A2 A3 B1 C1 VGND VPB VPWR X
.ENDS sky130_fd_sc_hd__o311a_1

.SUBCKT sky130_fd_sc_hd__xor3_1 A B C VGND VPB VPWR X
.ENDS sky130_fd_sc_hd__xor3_1

.SUBCKT sky130_fd_sc_hd__o21bai_1 A1 A2 B1_N VGND VPB VPWR Y
.ENDS sky130_fd_sc_hd__o21bai_1

.SUBCKT sky130_fd_sc_hd__a311oi_1 A1 A2 A3 B1 C1 VGND VPB VPWR Y
.ENDS sky130_fd_sc_hd__a311oi_1

.SUBCKT sky130_fd_sc_hd__o22ai_4 A1 A2 B1 B2 VGND VPB VPWR Y
.ENDS sky130_fd_sc_hd__o22ai_4

.SUBCKT sky130_fd_sc_hd__mux2i_1 A0 A1 S VGND VPB VPWR Y
.ENDS sky130_fd_sc_hd__mux2i_1

.SUBCKT sky130_fd_sc_hd__o31ai_4 A1 A2 A3 B1 VGND VPB VPWR Y
.ENDS sky130_fd_sc_hd__o31ai_4

.SUBCKT sky130_fd_sc_hd__or3_1 A B C VGND VPB VPWR X
.ENDS sky130_fd_sc_hd__or3_1

.SUBCKT sky130_fd_sc_hd__a211oi_1 A1 A2 B1 C1 VGND VPB VPWR Y
.ENDS sky130_fd_sc_hd__a211oi_1

.SUBCKT sky130_fd_sc_hd__a22o_1 A1 A2 B1 B2 VGND VPB VPWR X
.ENDS sky130_fd_sc_hd__a22o_1

.SUBCKT sky130_fd_sc_hd__mux2_2 A0 A1 S VGND VPB VPWR X
.ENDS sky130_fd_sc_hd__mux2_2

.SUBCKT sky130_fd_sc_hd__o31a_1 A1 A2 A3 B1 VGND VPB VPWR X
.ENDS sky130_fd_sc_hd__o31a_1

.SUBCKT sky130_fd_sc_hd__dfrtp_1 CLK D Q RESET_B VGND VPB VPWR
.ENDS sky130_fd_sc_hd__dfrtp_1

.SUBCKT sky130_fd_sc_hd__dfstp_2 CLK D Q SET_B VGND VPB VPWR
.ENDS sky130_fd_sc_hd__dfstp_2

.SUBCKT sky130_fd_sc_hd__conb_1 HI LO VGND VPB VPWR
.ENDS sky130_fd_sc_hd__conb_1

.SUBCKT sky130_fd_sc_hd__buf_4 A VGND VPB VPWR X
.ENDS sky130_fd_sc_hd__buf_4

.SUBCKT sky130_fd_sc_hd__inv_6 A VGND VPB VPWR Y
.ENDS sky130_fd_sc_hd__inv_6

.SUBCKT sky130_fd_sc_hd__clkinv_4 A VGND VPB VPWR Y
.ENDS sky130_fd_sc_hd__clkinv_4

.SUBCKT sky130_fd_sc_hd__bufinv_16 A VGND VPB VPWR Y
.ENDS sky130_fd_sc_hd__bufinv_16

.SUBCKT sky130_fd_sc_hd__clkinv_2 A VGND VPB VPWR Y
.ENDS sky130_fd_sc_hd__clkinv_2

.SUBCKT sky130_fd_sc_hd__inv_8 A VGND VPB VPWR Y
.ENDS sky130_fd_sc_hd__inv_8

.SUBCKT sky130_fd_sc_hd__clkinvlp_4 A VGND VPB VPWR Y
.ENDS sky130_fd_sc_hd__clkinvlp_4
